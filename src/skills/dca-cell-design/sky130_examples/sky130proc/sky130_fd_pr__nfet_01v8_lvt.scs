// sky130_fd_pr__nfet_01v8_lvt - Cadence Spectre bsim4, tt corner, 27C
// Generated by gen/gen_sky130_spectre.py from fossi continuous card (per-geometry
// flattened: rsh from wrapper swx_nrds = {89.1*nf/w+443.5}; binning auto-picked per geometry).
// NOTE: rsh is per-instance in ngspice (model-in-subckt); these cards are exact
// only at the geometries listed below. Re-run the generator for other sizes.
// l=0.15 w=10 nf=5 -> bin nlowvt_model.8  rsh=488.0500 delvto=0 (folded into vth0)
model nlowvt_model__w10nf5 bsim4 \
    type=n version=4.50 binunit=2 mobmod=0 \
    capmod=2 rdsmod=0 igcmod=0 igbmod=0 \
    rbodymod=1 trnqsmod=0 acnqsmod=0 fnoimod=1 \
    tnoimod=1 diomod=1 tempmod=0 permod=1 \
    geomod=0 rgatemod=0 epsrox=3.9 toxe=4.148E-9 \
    toxm=4.148E-9 dtox=0 xj=1.5E-7 ndep=1.7E17 \
    ngate=9.999999999999999E22 nsd=1E20 rshg=0.1 phin=0 \
    wint=2.6e-08 wl=0 wln=1 ww=0 \
    wwn=1 wwl=0 lint=1.2025e-08 ll=0 \
    lln=1 lw=0 lwn=1 lwl=0 \
    llc=0 lwc=0 lwlc=0 wlc=0 \
    wwc=0 wwlc=0 dwg=-1.33E-8 dwb=-1.08E-8 \
    xl=0 xw=0 dmcg=0 dmdg=0 \
    dmcgt=0 xgw=0 xgl=0 ngcon=1 \
    vth0=0.249959346666667 lvth0=-1.985141612666671E-9 vfb=0 k1=1.011211866666667 \
    lk1=-4.876429660666666E-8 k2=-0.21737859252 lk2=1.7355223637994E-8 k3=1.65 \
    k3b=1.6 w0=1E-7 lpe0=2.3802E-7 lpeb=-4.9152E-8 \
    vbm=-3 dvtp0=0 dvtp1=0 dvt0=0.07665 \
    dvt1=0.1252 dvt2=-0.05637 dvt0w=0 dvt1w=5.3E6 \
    dvt2w=-0.032 vfbsdoff=0 u0=0.01421071555 lu0=2.166698264775001E-10 \
    ua=-3.496851672833332E-9 lua=1.729222681883582E-16 ub=4.57941585E-18 lub=-2.719028563075E-25 \
    uc=1.863698448333334E-10 luc=-2.261771620175834E-17 ud=0 up=0 \
    lp=1 eu=1.67 vsat=1.819855189500001E5 lvsat=-1.786254255252507E-3 \
    a0=0 ags=1.005218833333333 lags=3.096873294166675E-8 b0=0 \
    b1=0 keta=0.1569286063 lketa=-4.276737497598501E-8 a1=0 \
    a2=0.38689047 rdsw=103.65 rdswmin=0 rdw=0 \
    rdwmin=0 rsw=0 rswmin=0 prwb=0 \
    prwg=0 wr=1 voff=-0.11934831869 lvoff=5.296050099455504E-9 \
    voffl=0 minv=0 nfactor=0.723459400166666 lnfactor=3.583940752490084E-7 \
    eta0=0.067637351756667 leta0=1.529144370447834E-9 etab=-0.077077273825 letab=9.70788263825875E-9 \
    dsub=0.58180516425 ldsub=-4.053136043728748E-8 cit=5E-6 cdsc=3.8556E-37 \
    cdscb=-1.1484E-4 cdscd=4.7984E-6 pclm=0.086824416666667 lpclm=9.59179572083335E-9 \
    pdiblc1=3.583688213883334 lpdiblc1=-4.029261769551058E-7 pdiblc2=0.064735802833333 lpdiblc2=-7.957785851858334E-9 \
    pdiblcb=0 drout=3.4946 pscbe1=4.5E8 pscbe2=1E-8 \
    pvag=0 delta=0.01 fprout=0 pdits=1.4427E-15 \
    pditsl=0 pditsd=0 lambda=0 vtl=0 \
    lc=0 xn=0 alpha0=1.687407635666667E-3 lalpha0=-1.627859334572167E-10 \
    alpha1=0 beta0=31.24083182666667 lbeta0=-3.496153888186668E-7 aigbacc=1 \
    bigbacc=0 cigbacc=0 nigbacc=1 aigbinv=0.35 \
    bigbinv=0.03 cigbinv=6E-3 eigbinv=1.1 nigbinv=3 \
    aigc=0.43 bigc=0.054 cigc=0.075 aigsd=0.43 \
    bigsd=0.054 cigsd=0.075 dlcig=0 nigc=1 \
    poxedge=1 pigcd=1 ntox=1 toxref=4.148E-9 \
    agidl=0 bgidl=2.3E9 cgidl=0.5 egidl=0.8 \
    noia=9E41 noib=1E27 noic=8E11 em=4.1E7 \
    af=1 ef=1.2 kf=0 lintnoi=-3E-7 \
    tnoia=2.5E7 tnoib=9.9E6 ntnoi=1 rnoia=0.912 \
    rnoib=0.26 xpart=0 cgso=2.392894381e-10 cgdo=2.392894381e-10 \
    cgbo=1e-14 ckappas=0.6 cf=1E-14 clc=1E-7 \
    cle=0.6 dlc=1.21071E-8 dwc=2.6E-8 vfbcv=-1 \
    noff=3.8661 voffcv=-0.16994 acde=0.38008 moin=23.81 \
    cgsl=2.310725e-11 cgdl=2.310725e-11 ijthsrev=0.1 ijthsfwd=0.1 \
    xjbvs=1 bvs=11.9 jss=2.75E-3 jsws=6E-10 \
    cjs=0.00121 mjs=0.42197 mjsws=1E-3 cjsws=3.230311424e-11 \
    cjswgs=1.795291232e-10 mjswgs=0.8 pbs=0.7477 pbsws=0.1 \
    pbswgs=0.79644 xrcrg1=12 xrcrg2=1 rbpb=50 \
    rbpd=50 rbps=50 rbdb=50 rbsb=50 \
    gbmin=1E-12 tnom=30 ute=-2.841387833333333 lute=1.462012276083332E-7 \
    kt1=-0.295119316666667 lkt1=-2.874265065833337E-9 kt1l=0 kt2=0.02122778 \
    lkt2=-5.743292291000001E-9 ua1=-2.42902207E-9 lua1=3.816539507165E-16 ub1=2.4443796E-18 \
    lub1=-4.0006627012E-25 uc1=5.2148775E-12 luc1=-5.195283211249999E-19 at=6.394335E4 \
    lat=2.4945216175E-3 prt=0 njs=1.2928 xtis=2 \
    tpb=1.2287E-3 tpbsw=0 tpbswg=0 tcj=7.92E-4 \
    tcjsw=1E-5 tcjswg=0 tvoff=0 tvfbsdoff=0 \
    saref=1.1E-6 sbref=1.1E-6 wlod=0 ku0=-2.7E-8 \
    kvsat=0.2 kvth0=7.9E-9 tku0=0 llodku0=0 \
    wlodku0=1 llodvth=0 wlodvth=1 lku0=0 \
    wku0=0 pku0=0 lkvth0=0 wkvth0=3E-7 \
    pkvth0=0 stk2=0 lodk2=1 steta0=0 \
    lodeta0=1 rsh=488.05

// l=0.15 w=20 nf=10 -> bin nlowvt_model.8  rsh=488.0500 delvto=0 (folded into vth0)
model nlowvt_model__w20nf10 bsim4 \
    type=n version=4.50 binunit=2 mobmod=0 \
    capmod=2 rdsmod=0 igcmod=0 igbmod=0 \
    rbodymod=1 trnqsmod=0 acnqsmod=0 fnoimod=1 \
    tnoimod=1 diomod=1 tempmod=0 permod=1 \
    geomod=0 rgatemod=0 epsrox=3.9 toxe=4.148E-9 \
    toxm=4.148E-9 dtox=0 xj=1.5E-7 ndep=1.7E17 \
    ngate=9.999999999999999E22 nsd=1E20 rshg=0.1 phin=0 \
    wint=2.6e-08 wl=0 wln=1 ww=0 \
    wwn=1 wwl=0 lint=1.2025e-08 ll=0 \
    lln=1 lw=0 lwn=1 lwl=0 \
    llc=0 lwc=0 lwlc=0 wlc=0 \
    wwc=0 wwlc=0 dwg=-1.33E-8 dwb=-1.08E-8 \
    xl=0 xw=0 dmcg=0 dmdg=0 \
    dmcgt=0 xgw=0 xgl=0 ngcon=1 \
    vth0=0.249959346666667 lvth0=-1.985141612666671E-9 vfb=0 k1=1.011211866666667 \
    lk1=-4.876429660666666E-8 k2=-0.21737859252 lk2=1.7355223637994E-8 k3=1.65 \
    k3b=1.6 w0=1E-7 lpe0=2.3802E-7 lpeb=-4.9152E-8 \
    vbm=-3 dvtp0=0 dvtp1=0 dvt0=0.07665 \
    dvt1=0.1252 dvt2=-0.05637 dvt0w=0 dvt1w=5.3E6 \
    dvt2w=-0.032 vfbsdoff=0 u0=0.01421071555 lu0=2.166698264775001E-10 \
    ua=-3.496851672833332E-9 lua=1.729222681883582E-16 ub=4.57941585E-18 lub=-2.719028563075E-25 \
    uc=1.863698448333334E-10 luc=-2.261771620175834E-17 ud=0 up=0 \
    lp=1 eu=1.67 vsat=1.819855189500001E5 lvsat=-1.786254255252507E-3 \
    a0=0 ags=1.005218833333333 lags=3.096873294166675E-8 b0=0 \
    b1=0 keta=0.1569286063 lketa=-4.276737497598501E-8 a1=0 \
    a2=0.38689047 rdsw=103.65 rdswmin=0 rdw=0 \
    rdwmin=0 rsw=0 rswmin=0 prwb=0 \
    prwg=0 wr=1 voff=-0.11934831869 lvoff=5.296050099455504E-9 \
    voffl=0 minv=0 nfactor=0.723459400166666 lnfactor=3.583940752490084E-7 \
    eta0=0.067637351756667 leta0=1.529144370447834E-9 etab=-0.077077273825 letab=9.70788263825875E-9 \
    dsub=0.58180516425 ldsub=-4.053136043728748E-8 cit=5E-6 cdsc=3.8556E-37 \
    cdscb=-1.1484E-4 cdscd=4.7984E-6 pclm=0.086824416666667 lpclm=9.59179572083335E-9 \
    pdiblc1=3.583688213883334 lpdiblc1=-4.029261769551058E-7 pdiblc2=0.064735802833333 lpdiblc2=-7.957785851858334E-9 \
    pdiblcb=0 drout=3.4946 pscbe1=4.5E8 pscbe2=1E-8 \
    pvag=0 delta=0.01 fprout=0 pdits=1.4427E-15 \
    pditsl=0 pditsd=0 lambda=0 vtl=0 \
    lc=0 xn=0 alpha0=1.687407635666667E-3 lalpha0=-1.627859334572167E-10 \
    alpha1=0 beta0=31.24083182666667 lbeta0=-3.496153888186668E-7 aigbacc=1 \
    bigbacc=0 cigbacc=0 nigbacc=1 aigbinv=0.35 \
    bigbinv=0.03 cigbinv=6E-3 eigbinv=1.1 nigbinv=3 \
    aigc=0.43 bigc=0.054 cigc=0.075 aigsd=0.43 \
    bigsd=0.054 cigsd=0.075 dlcig=0 nigc=1 \
    poxedge=1 pigcd=1 ntox=1 toxref=4.148E-9 \
    agidl=0 bgidl=2.3E9 cgidl=0.5 egidl=0.8 \
    noia=9E41 noib=1E27 noic=8E11 em=4.1E7 \
    af=1 ef=1.2 kf=0 lintnoi=-3E-7 \
    tnoia=2.5E7 tnoib=9.9E6 ntnoi=1 rnoia=0.912 \
    rnoib=0.26 xpart=0 cgso=2.392894381e-10 cgdo=2.392894381e-10 \
    cgbo=1e-14 ckappas=0.6 cf=1E-14 clc=1E-7 \
    cle=0.6 dlc=1.21071E-8 dwc=2.6E-8 vfbcv=-1 \
    noff=3.8661 voffcv=-0.16994 acde=0.38008 moin=23.81 \
    cgsl=2.310725e-11 cgdl=2.310725e-11 ijthsrev=0.1 ijthsfwd=0.1 \
    xjbvs=1 bvs=11.9 jss=2.75E-3 jsws=6E-10 \
    cjs=0.00121 mjs=0.42197 mjsws=1E-3 cjsws=3.230311424e-11 \
    cjswgs=1.795291232e-10 mjswgs=0.8 pbs=0.7477 pbsws=0.1 \
    pbswgs=0.79644 xrcrg1=12 xrcrg2=1 rbpb=50 \
    rbpd=50 rbps=50 rbdb=50 rbsb=50 \
    gbmin=1E-12 tnom=30 ute=-2.841387833333333 lute=1.462012276083332E-7 \
    kt1=-0.295119316666667 lkt1=-2.874265065833337E-9 kt1l=0 kt2=0.02122778 \
    lkt2=-5.743292291000001E-9 ua1=-2.42902207E-9 lua1=3.816539507165E-16 ub1=2.4443796E-18 \
    lub1=-4.0006627012E-25 uc1=5.2148775E-12 luc1=-5.195283211249999E-19 at=6.394335E4 \
    lat=2.4945216175E-3 prt=0 njs=1.2928 xtis=2 \
    tpb=1.2287E-3 tpbsw=0 tpbswg=0 tcj=7.92E-4 \
    tcjsw=1E-5 tcjswg=0 tvoff=0 tvfbsdoff=0 \
    saref=1.1E-6 sbref=1.1E-6 wlod=0 ku0=-2.7E-8 \
    kvsat=0.2 kvth0=7.9E-9 tku0=0 llodku0=0 \
    wlodku0=1 llodvth=0 wlodvth=1 lku0=0 \
    wku0=0 pku0=0 lkvth0=0 wkvth0=3E-7 \
    pkvth0=0 stk2=0 lodk2=1 steta0=0 \
    lodeta0=1 rsh=488.05

// l=0.15 w=50 nf=25 -> bin nlowvt_model.8  rsh=488.0500 delvto=0 (folded into vth0)
model nlowvt_model__w50nf25 bsim4 \
    type=n version=4.50 binunit=2 mobmod=0 \
    capmod=2 rdsmod=0 igcmod=0 igbmod=0 \
    rbodymod=1 trnqsmod=0 acnqsmod=0 fnoimod=1 \
    tnoimod=1 diomod=1 tempmod=0 permod=1 \
    geomod=0 rgatemod=0 epsrox=3.9 toxe=4.148E-9 \
    toxm=4.148E-9 dtox=0 xj=1.5E-7 ndep=1.7E17 \
    ngate=9.999999999999999E22 nsd=1E20 rshg=0.1 phin=0 \
    wint=2.6e-08 wl=0 wln=1 ww=0 \
    wwn=1 wwl=0 lint=1.2025e-08 ll=0 \
    lln=1 lw=0 lwn=1 lwl=0 \
    llc=0 lwc=0 lwlc=0 wlc=0 \
    wwc=0 wwlc=0 dwg=-1.33E-8 dwb=-1.08E-8 \
    xl=0 xw=0 dmcg=0 dmdg=0 \
    dmcgt=0 xgw=0 xgl=0 ngcon=1 \
    vth0=0.249959346666667 lvth0=-1.985141612666671E-9 vfb=0 k1=1.011211866666667 \
    lk1=-4.876429660666666E-8 k2=-0.21737859252 lk2=1.7355223637994E-8 k3=1.65 \
    k3b=1.6 w0=1E-7 lpe0=2.3802E-7 lpeb=-4.9152E-8 \
    vbm=-3 dvtp0=0 dvtp1=0 dvt0=0.07665 \
    dvt1=0.1252 dvt2=-0.05637 dvt0w=0 dvt1w=5.3E6 \
    dvt2w=-0.032 vfbsdoff=0 u0=0.01421071555 lu0=2.166698264775001E-10 \
    ua=-3.496851672833332E-9 lua=1.729222681883582E-16 ub=4.57941585E-18 lub=-2.719028563075E-25 \
    uc=1.863698448333334E-10 luc=-2.261771620175834E-17 ud=0 up=0 \
    lp=1 eu=1.67 vsat=1.819855189500001E5 lvsat=-1.786254255252507E-3 \
    a0=0 ags=1.005218833333333 lags=3.096873294166675E-8 b0=0 \
    b1=0 keta=0.1569286063 lketa=-4.276737497598501E-8 a1=0 \
    a2=0.38689047 rdsw=103.65 rdswmin=0 rdw=0 \
    rdwmin=0 rsw=0 rswmin=0 prwb=0 \
    prwg=0 wr=1 voff=-0.11934831869 lvoff=5.296050099455504E-9 \
    voffl=0 minv=0 nfactor=0.723459400166666 lnfactor=3.583940752490084E-7 \
    eta0=0.067637351756667 leta0=1.529144370447834E-9 etab=-0.077077273825 letab=9.70788263825875E-9 \
    dsub=0.58180516425 ldsub=-4.053136043728748E-8 cit=5E-6 cdsc=3.8556E-37 \
    cdscb=-1.1484E-4 cdscd=4.7984E-6 pclm=0.086824416666667 lpclm=9.59179572083335E-9 \
    pdiblc1=3.583688213883334 lpdiblc1=-4.029261769551058E-7 pdiblc2=0.064735802833333 lpdiblc2=-7.957785851858334E-9 \
    pdiblcb=0 drout=3.4946 pscbe1=4.5E8 pscbe2=1E-8 \
    pvag=0 delta=0.01 fprout=0 pdits=1.4427E-15 \
    pditsl=0 pditsd=0 lambda=0 vtl=0 \
    lc=0 xn=0 alpha0=1.687407635666667E-3 lalpha0=-1.627859334572167E-10 \
    alpha1=0 beta0=31.24083182666667 lbeta0=-3.496153888186668E-7 aigbacc=1 \
    bigbacc=0 cigbacc=0 nigbacc=1 aigbinv=0.35 \
    bigbinv=0.03 cigbinv=6E-3 eigbinv=1.1 nigbinv=3 \
    aigc=0.43 bigc=0.054 cigc=0.075 aigsd=0.43 \
    bigsd=0.054 cigsd=0.075 dlcig=0 nigc=1 \
    poxedge=1 pigcd=1 ntox=1 toxref=4.148E-9 \
    agidl=0 bgidl=2.3E9 cgidl=0.5 egidl=0.8 \
    noia=9E41 noib=1E27 noic=8E11 em=4.1E7 \
    af=1 ef=1.2 kf=0 lintnoi=-3E-7 \
    tnoia=2.5E7 tnoib=9.9E6 ntnoi=1 rnoia=0.912 \
    rnoib=0.26 xpart=0 cgso=2.392894381e-10 cgdo=2.392894381e-10 \
    cgbo=1e-14 ckappas=0.6 cf=1E-14 clc=1E-7 \
    cle=0.6 dlc=1.21071E-8 dwc=2.6E-8 vfbcv=-1 \
    noff=3.8661 voffcv=-0.16994 acde=0.38008 moin=23.81 \
    cgsl=2.310725e-11 cgdl=2.310725e-11 ijthsrev=0.1 ijthsfwd=0.1 \
    xjbvs=1 bvs=11.9 jss=2.75E-3 jsws=6E-10 \
    cjs=0.00121 mjs=0.42197 mjsws=1E-3 cjsws=3.230311424e-11 \
    cjswgs=1.795291232e-10 mjswgs=0.8 pbs=0.7477 pbsws=0.1 \
    pbswgs=0.79644 xrcrg1=12 xrcrg2=1 rbpb=50 \
    rbpd=50 rbps=50 rbdb=50 rbsb=50 \
    gbmin=1E-12 tnom=30 ute=-2.841387833333333 lute=1.462012276083332E-7 \
    kt1=-0.295119316666667 lkt1=-2.874265065833337E-9 kt1l=0 kt2=0.02122778 \
    lkt2=-5.743292291000001E-9 ua1=-2.42902207E-9 lua1=3.816539507165E-16 ub1=2.4443796E-18 \
    lub1=-4.0006627012E-25 uc1=5.2148775E-12 luc1=-5.195283211249999E-19 at=6.394335E4 \
    lat=2.4945216175E-3 prt=0 njs=1.2928 xtis=2 \
    tpb=1.2287E-3 tpbsw=0 tpbswg=0 tcj=7.92E-4 \
    tcjsw=1E-5 tcjswg=0 tvoff=0 tvfbsdoff=0 \
    saref=1.1E-6 sbref=1.1E-6 wlod=0 ku0=-2.7E-8 \
    kvsat=0.2 kvth0=7.9E-9 tku0=0 llodku0=0 \
    wlodku0=1 llodvth=0 wlodvth=1 lku0=0 \
    wku0=0 pku0=0 lkvth0=0 wkvth0=3E-7 \
    pkvth0=0 stk2=0 lodk2=1 steta0=0 \
    lodeta0=1 rsh=488.05

// l=0.15 w=100 nf=50 -> bin nlowvt_model.8  rsh=488.0500 delvto=0 (folded into vth0)
model nlowvt_model__w100nf50 bsim4 \
    type=n version=4.50 binunit=2 mobmod=0 \
    capmod=2 rdsmod=0 igcmod=0 igbmod=0 \
    rbodymod=1 trnqsmod=0 acnqsmod=0 fnoimod=1 \
    tnoimod=1 diomod=1 tempmod=0 permod=1 \
    geomod=0 rgatemod=0 epsrox=3.9 toxe=4.148E-9 \
    toxm=4.148E-9 dtox=0 xj=1.5E-7 ndep=1.7E17 \
    ngate=9.999999999999999E22 nsd=1E20 rshg=0.1 phin=0 \
    wint=2.6e-08 wl=0 wln=1 ww=0 \
    wwn=1 wwl=0 lint=1.2025e-08 ll=0 \
    lln=1 lw=0 lwn=1 lwl=0 \
    llc=0 lwc=0 lwlc=0 wlc=0 \
    wwc=0 wwlc=0 dwg=-1.33E-8 dwb=-1.08E-8 \
    xl=0 xw=0 dmcg=0 dmdg=0 \
    dmcgt=0 xgw=0 xgl=0 ngcon=1 \
    vth0=0.249959346666667 lvth0=-1.985141612666671E-9 vfb=0 k1=1.011211866666667 \
    lk1=-4.876429660666666E-8 k2=-0.21737859252 lk2=1.7355223637994E-8 k3=1.65 \
    k3b=1.6 w0=1E-7 lpe0=2.3802E-7 lpeb=-4.9152E-8 \
    vbm=-3 dvtp0=0 dvtp1=0 dvt0=0.07665 \
    dvt1=0.1252 dvt2=-0.05637 dvt0w=0 dvt1w=5.3E6 \
    dvt2w=-0.032 vfbsdoff=0 u0=0.01421071555 lu0=2.166698264775001E-10 \
    ua=-3.496851672833332E-9 lua=1.729222681883582E-16 ub=4.57941585E-18 lub=-2.719028563075E-25 \
    uc=1.863698448333334E-10 luc=-2.261771620175834E-17 ud=0 up=0 \
    lp=1 eu=1.67 vsat=1.819855189500001E5 lvsat=-1.786254255252507E-3 \
    a0=0 ags=1.005218833333333 lags=3.096873294166675E-8 b0=0 \
    b1=0 keta=0.1569286063 lketa=-4.276737497598501E-8 a1=0 \
    a2=0.38689047 rdsw=103.65 rdswmin=0 rdw=0 \
    rdwmin=0 rsw=0 rswmin=0 prwb=0 \
    prwg=0 wr=1 voff=-0.11934831869 lvoff=5.296050099455504E-9 \
    voffl=0 minv=0 nfactor=0.723459400166666 lnfactor=3.583940752490084E-7 \
    eta0=0.067637351756667 leta0=1.529144370447834E-9 etab=-0.077077273825 letab=9.70788263825875E-9 \
    dsub=0.58180516425 ldsub=-4.053136043728748E-8 cit=5E-6 cdsc=3.8556E-37 \
    cdscb=-1.1484E-4 cdscd=4.7984E-6 pclm=0.086824416666667 lpclm=9.59179572083335E-9 \
    pdiblc1=3.583688213883334 lpdiblc1=-4.029261769551058E-7 pdiblc2=0.064735802833333 lpdiblc2=-7.957785851858334E-9 \
    pdiblcb=0 drout=3.4946 pscbe1=4.5E8 pscbe2=1E-8 \
    pvag=0 delta=0.01 fprout=0 pdits=1.4427E-15 \
    pditsl=0 pditsd=0 lambda=0 vtl=0 \
    lc=0 xn=0 alpha0=1.687407635666667E-3 lalpha0=-1.627859334572167E-10 \
    alpha1=0 beta0=31.24083182666667 lbeta0=-3.496153888186668E-7 aigbacc=1 \
    bigbacc=0 cigbacc=0 nigbacc=1 aigbinv=0.35 \
    bigbinv=0.03 cigbinv=6E-3 eigbinv=1.1 nigbinv=3 \
    aigc=0.43 bigc=0.054 cigc=0.075 aigsd=0.43 \
    bigsd=0.054 cigsd=0.075 dlcig=0 nigc=1 \
    poxedge=1 pigcd=1 ntox=1 toxref=4.148E-9 \
    agidl=0 bgidl=2.3E9 cgidl=0.5 egidl=0.8 \
    noia=9E41 noib=1E27 noic=8E11 em=4.1E7 \
    af=1 ef=1.2 kf=0 lintnoi=-3E-7 \
    tnoia=2.5E7 tnoib=9.9E6 ntnoi=1 rnoia=0.912 \
    rnoib=0.26 xpart=0 cgso=2.392894381e-10 cgdo=2.392894381e-10 \
    cgbo=1e-14 ckappas=0.6 cf=1E-14 clc=1E-7 \
    cle=0.6 dlc=1.21071E-8 dwc=2.6E-8 vfbcv=-1 \
    noff=3.8661 voffcv=-0.16994 acde=0.38008 moin=23.81 \
    cgsl=2.310725e-11 cgdl=2.310725e-11 ijthsrev=0.1 ijthsfwd=0.1 \
    xjbvs=1 bvs=11.9 jss=2.75E-3 jsws=6E-10 \
    cjs=0.00121 mjs=0.42197 mjsws=1E-3 cjsws=3.230311424e-11 \
    cjswgs=1.795291232e-10 mjswgs=0.8 pbs=0.7477 pbsws=0.1 \
    pbswgs=0.79644 xrcrg1=12 xrcrg2=1 rbpb=50 \
    rbpd=50 rbps=50 rbdb=50 rbsb=50 \
    gbmin=1E-12 tnom=30 ute=-2.841387833333333 lute=1.462012276083332E-7 \
    kt1=-0.295119316666667 lkt1=-2.874265065833337E-9 kt1l=0 kt2=0.02122778 \
    lkt2=-5.743292291000001E-9 ua1=-2.42902207E-9 lua1=3.816539507165E-16 ub1=2.4443796E-18 \
    lub1=-4.0006627012E-25 uc1=5.2148775E-12 luc1=-5.195283211249999E-19 at=6.394335E4 \
    lat=2.4945216175E-3 prt=0 njs=1.2928 xtis=2 \
    tpb=1.2287E-3 tpbsw=0 tpbswg=0 tcj=7.92E-4 \
    tcjsw=1E-5 tcjswg=0 tvoff=0 tvfbsdoff=0 \
    saref=1.1E-6 sbref=1.1E-6 wlod=0 ku0=-2.7E-8 \
    kvsat=0.2 kvth0=7.9E-9 tku0=0 llodku0=0 \
    wlodku0=1 llodvth=0 wlodvth=1 lku0=0 \
    wku0=0 pku0=0 lkvth0=0 wkvth0=3E-7 \
    pkvth0=0 stk2=0 lodk2=1 steta0=0 \
    lodeta0=1 rsh=488.05

// l=0.15 w=61.7 nf=31 -> bin nlowvt_model.8  rsh=488.2666 delvto=0 (folded into vth0)
model nlowvt_model__w61p7nf31 bsim4 \
    type=n version=4.50 binunit=2 mobmod=0 \
    capmod=2 rdsmod=0 igcmod=0 igbmod=0 \
    rbodymod=1 trnqsmod=0 acnqsmod=0 fnoimod=1 \
    tnoimod=1 diomod=1 tempmod=0 permod=1 \
    geomod=0 rgatemod=0 epsrox=3.9 toxe=4.148E-9 \
    toxm=4.148E-9 dtox=0 xj=1.5E-7 ndep=1.7E17 \
    ngate=9.999999999999999E22 nsd=1E20 rshg=0.1 phin=0 \
    wint=2.6e-08 wl=0 wln=1 ww=0 \
    wwn=1 wwl=0 lint=1.2025e-08 ll=0 \
    lln=1 lw=0 lwn=1 lwl=0 \
    llc=0 lwc=0 lwlc=0 wlc=0 \
    wwc=0 wwlc=0 dwg=-1.33E-8 dwb=-1.08E-8 \
    xl=0 xw=0 dmcg=0 dmdg=0 \
    dmcgt=0 xgw=0 xgl=0 ngcon=1 \
    vth0=0.249959346666667 lvth0=-1.985141612666671E-9 vfb=0 k1=1.011211866666667 \
    lk1=-4.876429660666666E-8 k2=-0.21737859252 lk2=1.7355223637994E-8 k3=1.65 \
    k3b=1.6 w0=1E-7 lpe0=2.3802E-7 lpeb=-4.9152E-8 \
    vbm=-3 dvtp0=0 dvtp1=0 dvt0=0.07665 \
    dvt1=0.1252 dvt2=-0.05637 dvt0w=0 dvt1w=5.3E6 \
    dvt2w=-0.032 vfbsdoff=0 u0=0.01421071555 lu0=2.166698264775001E-10 \
    ua=-3.496851672833332E-9 lua=1.729222681883582E-16 ub=4.57941585E-18 lub=-2.719028563075E-25 \
    uc=1.863698448333334E-10 luc=-2.261771620175834E-17 ud=0 up=0 \
    lp=1 eu=1.67 vsat=1.819855189500001E5 lvsat=-1.786254255252507E-3 \
    a0=0 ags=1.005218833333333 lags=3.096873294166675E-8 b0=0 \
    b1=0 keta=0.1569286063 lketa=-4.276737497598501E-8 a1=0 \
    a2=0.38689047 rdsw=103.65 rdswmin=0 rdw=0 \
    rdwmin=0 rsw=0 rswmin=0 prwb=0 \
    prwg=0 wr=1 voff=-0.11934831869 lvoff=5.296050099455504E-9 \
    voffl=0 minv=0 nfactor=0.723459400166666 lnfactor=3.583940752490084E-7 \
    eta0=0.067637351756667 leta0=1.529144370447834E-9 etab=-0.077077273825 letab=9.70788263825875E-9 \
    dsub=0.58180516425 ldsub=-4.053136043728748E-8 cit=5E-6 cdsc=3.8556E-37 \
    cdscb=-1.1484E-4 cdscd=4.7984E-6 pclm=0.086824416666667 lpclm=9.59179572083335E-9 \
    pdiblc1=3.583688213883334 lpdiblc1=-4.029261769551058E-7 pdiblc2=0.064735802833333 lpdiblc2=-7.957785851858334E-9 \
    pdiblcb=0 drout=3.4946 pscbe1=4.5E8 pscbe2=1E-8 \
    pvag=0 delta=0.01 fprout=0 pdits=1.4427E-15 \
    pditsl=0 pditsd=0 lambda=0 vtl=0 \
    lc=0 xn=0 alpha0=1.687407635666667E-3 lalpha0=-1.627859334572167E-10 \
    alpha1=0 beta0=31.24083182666667 lbeta0=-3.496153888186668E-7 aigbacc=1 \
    bigbacc=0 cigbacc=0 nigbacc=1 aigbinv=0.35 \
    bigbinv=0.03 cigbinv=6E-3 eigbinv=1.1 nigbinv=3 \
    aigc=0.43 bigc=0.054 cigc=0.075 aigsd=0.43 \
    bigsd=0.054 cigsd=0.075 dlcig=0 nigc=1 \
    poxedge=1 pigcd=1 ntox=1 toxref=4.148E-9 \
    agidl=0 bgidl=2.3E9 cgidl=0.5 egidl=0.8 \
    noia=9E41 noib=1E27 noic=8E11 em=4.1E7 \
    af=1 ef=1.2 kf=0 lintnoi=-3E-7 \
    tnoia=2.5E7 tnoib=9.9E6 ntnoi=1 rnoia=0.912 \
    rnoib=0.26 xpart=0 cgso=2.392894381e-10 cgdo=2.392894381e-10 \
    cgbo=1e-14 ckappas=0.6 cf=1E-14 clc=1E-7 \
    cle=0.6 dlc=1.21071E-8 dwc=2.6E-8 vfbcv=-1 \
    noff=3.8661 voffcv=-0.16994 acde=0.38008 moin=23.81 \
    cgsl=2.310725e-11 cgdl=2.310725e-11 ijthsrev=0.1 ijthsfwd=0.1 \
    xjbvs=1 bvs=11.9 jss=2.75E-3 jsws=6E-10 \
    cjs=0.00121 mjs=0.42197 mjsws=1E-3 cjsws=3.230311424e-11 \
    cjswgs=1.795291232e-10 mjswgs=0.8 pbs=0.7477 pbsws=0.1 \
    pbswgs=0.79644 xrcrg1=12 xrcrg2=1 rbpb=50 \
    rbpd=50 rbps=50 rbdb=50 rbsb=50 \
    gbmin=1E-12 tnom=30 ute=-2.841387833333333 lute=1.462012276083332E-7 \
    kt1=-0.295119316666667 lkt1=-2.874265065833337E-9 kt1l=0 kt2=0.02122778 \
    lkt2=-5.743292291000001E-9 ua1=-2.42902207E-9 lua1=3.816539507165E-16 ub1=2.4443796E-18 \
    lub1=-4.0006627012E-25 uc1=5.2148775E-12 luc1=-5.195283211249999E-19 at=6.394335E4 \
    lat=2.4945216175E-3 prt=0 njs=1.2928 xtis=2 \
    tpb=1.2287E-3 tpbsw=0 tpbswg=0 tcj=7.92E-4 \
    tcjsw=1E-5 tcjswg=0 tvoff=0 tvfbsdoff=0 \
    saref=1.1E-6 sbref=1.1E-6 wlod=0 ku0=-2.7E-8 \
    kvsat=0.2 kvth0=7.9E-9 tku0=0 llodku0=0 \
    wlodku0=1 llodvth=0 wlodvth=1 lku0=0 \
    wku0=0 pku0=0 lkvth0=0 wkvth0=3E-7 \
    pkvth0=0 stk2=0 lodk2=1 steta0=0 \
    lodeta0=1 rsh=488.26661264181524

// l=0.15 w=43.3 nf=22 -> bin nlowvt_model.8  rsh=488.7702 delvto=0 (folded into vth0)
model nlowvt_model__w43p3nf22 bsim4 \
    type=n version=4.50 binunit=2 mobmod=0 \
    capmod=2 rdsmod=0 igcmod=0 igbmod=0 \
    rbodymod=1 trnqsmod=0 acnqsmod=0 fnoimod=1 \
    tnoimod=1 diomod=1 tempmod=0 permod=1 \
    geomod=0 rgatemod=0 epsrox=3.9 toxe=4.148E-9 \
    toxm=4.148E-9 dtox=0 xj=1.5E-7 ndep=1.7E17 \
    ngate=9.999999999999999E22 nsd=1E20 rshg=0.1 phin=0 \
    wint=2.6e-08 wl=0 wln=1 ww=0 \
    wwn=1 wwl=0 lint=1.2025e-08 ll=0 \
    lln=1 lw=0 lwn=1 lwl=0 \
    llc=0 lwc=0 lwlc=0 wlc=0 \
    wwc=0 wwlc=0 dwg=-1.33E-8 dwb=-1.08E-8 \
    xl=0 xw=0 dmcg=0 dmdg=0 \
    dmcgt=0 xgw=0 xgl=0 ngcon=1 \
    vth0=0.249959346666667 lvth0=-1.985141612666671E-9 vfb=0 k1=1.011211866666667 \
    lk1=-4.876429660666666E-8 k2=-0.21737859252 lk2=1.7355223637994E-8 k3=1.65 \
    k3b=1.6 w0=1E-7 lpe0=2.3802E-7 lpeb=-4.9152E-8 \
    vbm=-3 dvtp0=0 dvtp1=0 dvt0=0.07665 \
    dvt1=0.1252 dvt2=-0.05637 dvt0w=0 dvt1w=5.3E6 \
    dvt2w=-0.032 vfbsdoff=0 u0=0.01421071555 lu0=2.166698264775001E-10 \
    ua=-3.496851672833332E-9 lua=1.729222681883582E-16 ub=4.57941585E-18 lub=-2.719028563075E-25 \
    uc=1.863698448333334E-10 luc=-2.261771620175834E-17 ud=0 up=0 \
    lp=1 eu=1.67 vsat=1.819855189500001E5 lvsat=-1.786254255252507E-3 \
    a0=0 ags=1.005218833333333 lags=3.096873294166675E-8 b0=0 \
    b1=0 keta=0.1569286063 lketa=-4.276737497598501E-8 a1=0 \
    a2=0.38689047 rdsw=103.65 rdswmin=0 rdw=0 \
    rdwmin=0 rsw=0 rswmin=0 prwb=0 \
    prwg=0 wr=1 voff=-0.11934831869 lvoff=5.296050099455504E-9 \
    voffl=0 minv=0 nfactor=0.723459400166666 lnfactor=3.583940752490084E-7 \
    eta0=0.067637351756667 leta0=1.529144370447834E-9 etab=-0.077077273825 letab=9.70788263825875E-9 \
    dsub=0.58180516425 ldsub=-4.053136043728748E-8 cit=5E-6 cdsc=3.8556E-37 \
    cdscb=-1.1484E-4 cdscd=4.7984E-6 pclm=0.086824416666667 lpclm=9.59179572083335E-9 \
    pdiblc1=3.583688213883334 lpdiblc1=-4.029261769551058E-7 pdiblc2=0.064735802833333 lpdiblc2=-7.957785851858334E-9 \
    pdiblcb=0 drout=3.4946 pscbe1=4.5E8 pscbe2=1E-8 \
    pvag=0 delta=0.01 fprout=0 pdits=1.4427E-15 \
    pditsl=0 pditsd=0 lambda=0 vtl=0 \
    lc=0 xn=0 alpha0=1.687407635666667E-3 lalpha0=-1.627859334572167E-10 \
    alpha1=0 beta0=31.24083182666667 lbeta0=-3.496153888186668E-7 aigbacc=1 \
    bigbacc=0 cigbacc=0 nigbacc=1 aigbinv=0.35 \
    bigbinv=0.03 cigbinv=6E-3 eigbinv=1.1 nigbinv=3 \
    aigc=0.43 bigc=0.054 cigc=0.075 aigsd=0.43 \
    bigsd=0.054 cigsd=0.075 dlcig=0 nigc=1 \
    poxedge=1 pigcd=1 ntox=1 toxref=4.148E-9 \
    agidl=0 bgidl=2.3E9 cgidl=0.5 egidl=0.8 \
    noia=9E41 noib=1E27 noic=8E11 em=4.1E7 \
    af=1 ef=1.2 kf=0 lintnoi=-3E-7 \
    tnoia=2.5E7 tnoib=9.9E6 ntnoi=1 rnoia=0.912 \
    rnoib=0.26 xpart=0 cgso=2.392894381e-10 cgdo=2.392894381e-10 \
    cgbo=1e-14 ckappas=0.6 cf=1E-14 clc=1E-7 \
    cle=0.6 dlc=1.21071E-8 dwc=2.6E-8 vfbcv=-1 \
    noff=3.8661 voffcv=-0.16994 acde=0.38008 moin=23.81 \
    cgsl=2.310725e-11 cgdl=2.310725e-11 ijthsrev=0.1 ijthsfwd=0.1 \
    xjbvs=1 bvs=11.9 jss=2.75E-3 jsws=6E-10 \
    cjs=0.00121 mjs=0.42197 mjsws=1E-3 cjsws=3.230311424e-11 \
    cjswgs=1.795291232e-10 mjswgs=0.8 pbs=0.7477 pbsws=0.1 \
    pbswgs=0.79644 xrcrg1=12 xrcrg2=1 rbpb=50 \
    rbpd=50 rbps=50 rbdb=50 rbsb=50 \
    gbmin=1E-12 tnom=30 ute=-2.841387833333333 lute=1.462012276083332E-7 \
    kt1=-0.295119316666667 lkt1=-2.874265065833337E-9 kt1l=0 kt2=0.02122778 \
    lkt2=-5.743292291000001E-9 ua1=-2.42902207E-9 lua1=3.816539507165E-16 ub1=2.4443796E-18 \
    lub1=-4.0006627012E-25 uc1=5.2148775E-12 luc1=-5.195283211249999E-19 at=6.394335E4 \
    lat=2.4945216175E-3 prt=0 njs=1.2928 xtis=2 \
    tpb=1.2287E-3 tpbsw=0 tpbswg=0 tcj=7.92E-4 \
    tcjsw=1E-5 tcjswg=0 tvoff=0 tvfbsdoff=0 \
    saref=1.1E-6 sbref=1.1E-6 wlod=0 ku0=-2.7E-8 \
    kvsat=0.2 kvth0=7.9E-9 tku0=0 llodku0=0 \
    wlodku0=1 llodvth=0 wlodvth=1 lku0=0 \
    wku0=0 pku0=0 lkvth0=0 wkvth0=3E-7 \
    pkvth0=0 stk2=0 lodk2=1 steta0=0 \
    lodeta0=1 rsh=488.770207852194

// l=0.15 w=35.3 nf=18 -> bin nlowvt_model.8  rsh=488.9334 delvto=0 (folded into vth0)
model nlowvt_model__w35p3nf18 bsim4 \
    type=n version=4.50 binunit=2 mobmod=0 \
    capmod=2 rdsmod=0 igcmod=0 igbmod=0 \
    rbodymod=1 trnqsmod=0 acnqsmod=0 fnoimod=1 \
    tnoimod=1 diomod=1 tempmod=0 permod=1 \
    geomod=0 rgatemod=0 epsrox=3.9 toxe=4.148E-9 \
    toxm=4.148E-9 dtox=0 xj=1.5E-7 ndep=1.7E17 \
    ngate=9.999999999999999E22 nsd=1E20 rshg=0.1 phin=0 \
    wint=2.6e-08 wl=0 wln=1 ww=0 \
    wwn=1 wwl=0 lint=1.2025e-08 ll=0 \
    lln=1 lw=0 lwn=1 lwl=0 \
    llc=0 lwc=0 lwlc=0 wlc=0 \
    wwc=0 wwlc=0 dwg=-1.33E-8 dwb=-1.08E-8 \
    xl=0 xw=0 dmcg=0 dmdg=0 \
    dmcgt=0 xgw=0 xgl=0 ngcon=1 \
    vth0=0.249959346666667 lvth0=-1.985141612666671E-9 vfb=0 k1=1.011211866666667 \
    lk1=-4.876429660666666E-8 k2=-0.21737859252 lk2=1.7355223637994E-8 k3=1.65 \
    k3b=1.6 w0=1E-7 lpe0=2.3802E-7 lpeb=-4.9152E-8 \
    vbm=-3 dvtp0=0 dvtp1=0 dvt0=0.07665 \
    dvt1=0.1252 dvt2=-0.05637 dvt0w=0 dvt1w=5.3E6 \
    dvt2w=-0.032 vfbsdoff=0 u0=0.01421071555 lu0=2.166698264775001E-10 \
    ua=-3.496851672833332E-9 lua=1.729222681883582E-16 ub=4.57941585E-18 lub=-2.719028563075E-25 \
    uc=1.863698448333334E-10 luc=-2.261771620175834E-17 ud=0 up=0 \
    lp=1 eu=1.67 vsat=1.819855189500001E5 lvsat=-1.786254255252507E-3 \
    a0=0 ags=1.005218833333333 lags=3.096873294166675E-8 b0=0 \
    b1=0 keta=0.1569286063 lketa=-4.276737497598501E-8 a1=0 \
    a2=0.38689047 rdsw=103.65 rdswmin=0 rdw=0 \
    rdwmin=0 rsw=0 rswmin=0 prwb=0 \
    prwg=0 wr=1 voff=-0.11934831869 lvoff=5.296050099455504E-9 \
    voffl=0 minv=0 nfactor=0.723459400166666 lnfactor=3.583940752490084E-7 \
    eta0=0.067637351756667 leta0=1.529144370447834E-9 etab=-0.077077273825 letab=9.70788263825875E-9 \
    dsub=0.58180516425 ldsub=-4.053136043728748E-8 cit=5E-6 cdsc=3.8556E-37 \
    cdscb=-1.1484E-4 cdscd=4.7984E-6 pclm=0.086824416666667 lpclm=9.59179572083335E-9 \
    pdiblc1=3.583688213883334 lpdiblc1=-4.029261769551058E-7 pdiblc2=0.064735802833333 lpdiblc2=-7.957785851858334E-9 \
    pdiblcb=0 drout=3.4946 pscbe1=4.5E8 pscbe2=1E-8 \
    pvag=0 delta=0.01 fprout=0 pdits=1.4427E-15 \
    pditsl=0 pditsd=0 lambda=0 vtl=0 \
    lc=0 xn=0 alpha0=1.687407635666667E-3 lalpha0=-1.627859334572167E-10 \
    alpha1=0 beta0=31.24083182666667 lbeta0=-3.496153888186668E-7 aigbacc=1 \
    bigbacc=0 cigbacc=0 nigbacc=1 aigbinv=0.35 \
    bigbinv=0.03 cigbinv=6E-3 eigbinv=1.1 nigbinv=3 \
    aigc=0.43 bigc=0.054 cigc=0.075 aigsd=0.43 \
    bigsd=0.054 cigsd=0.075 dlcig=0 nigc=1 \
    poxedge=1 pigcd=1 ntox=1 toxref=4.148E-9 \
    agidl=0 bgidl=2.3E9 cgidl=0.5 egidl=0.8 \
    noia=9E41 noib=1E27 noic=8E11 em=4.1E7 \
    af=1 ef=1.2 kf=0 lintnoi=-3E-7 \
    tnoia=2.5E7 tnoib=9.9E6 ntnoi=1 rnoia=0.912 \
    rnoib=0.26 xpart=0 cgso=2.392894381e-10 cgdo=2.392894381e-10 \
    cgbo=1e-14 ckappas=0.6 cf=1E-14 clc=1E-7 \
    cle=0.6 dlc=1.21071E-8 dwc=2.6E-8 vfbcv=-1 \
    noff=3.8661 voffcv=-0.16994 acde=0.38008 moin=23.81 \
    cgsl=2.310725e-11 cgdl=2.310725e-11 ijthsrev=0.1 ijthsfwd=0.1 \
    xjbvs=1 bvs=11.9 jss=2.75E-3 jsws=6E-10 \
    cjs=0.00121 mjs=0.42197 mjsws=1E-3 cjsws=3.230311424e-11 \
    cjswgs=1.795291232e-10 mjswgs=0.8 pbs=0.7477 pbsws=0.1 \
    pbswgs=0.79644 xrcrg1=12 xrcrg2=1 rbpb=50 \
    rbpd=50 rbps=50 rbdb=50 rbsb=50 \
    gbmin=1E-12 tnom=30 ute=-2.841387833333333 lute=1.462012276083332E-7 \
    kt1=-0.295119316666667 lkt1=-2.874265065833337E-9 kt1l=0 kt2=0.02122778 \
    lkt2=-5.743292291000001E-9 ua1=-2.42902207E-9 lua1=3.816539507165E-16 ub1=2.4443796E-18 \
    lub1=-4.0006627012E-25 uc1=5.2148775E-12 luc1=-5.195283211249999E-19 at=6.394335E4 \
    lat=2.4945216175E-3 prt=0 njs=1.2928 xtis=2 \
    tpb=1.2287E-3 tpbsw=0 tpbswg=0 tcj=7.92E-4 \
    tcjsw=1E-5 tcjswg=0 tvoff=0 tvfbsdoff=0 \
    saref=1.1E-6 sbref=1.1E-6 wlod=0 ku0=-2.7E-8 \
    kvsat=0.2 kvth0=7.9E-9 tku0=0 llodku0=0 \
    wlodku0=1 llodvth=0 wlodvth=1 lku0=0 \
    wku0=0 pku0=0 lkvth0=0 wkvth0=3E-7 \
    pkvth0=0 stk2=0 lodk2=1 steta0=0 \
    lodeta0=1 rsh=488.9334277620397

// l=0.15 w=35.3 nf=20 -> bin nlowvt_model.8  rsh=493.9816 delvto=0 (folded into vth0)
model nlowvt_model__w35p3nf20 bsim4 \
    type=n version=4.50 binunit=2 mobmod=0 \
    capmod=2 rdsmod=0 igcmod=0 igbmod=0 \
    rbodymod=1 trnqsmod=0 acnqsmod=0 fnoimod=1 \
    tnoimod=1 diomod=1 tempmod=0 permod=1 \
    geomod=0 rgatemod=0 epsrox=3.9 toxe=4.148E-9 \
    toxm=4.148E-9 dtox=0 xj=1.5E-7 ndep=1.7E17 \
    ngate=9.999999999999999E22 nsd=1E20 rshg=0.1 phin=0 \
    wint=2.6e-08 wl=0 wln=1 ww=0 \
    wwn=1 wwl=0 lint=1.2025e-08 ll=0 \
    lln=1 lw=0 lwn=1 lwl=0 \
    llc=0 lwc=0 lwlc=0 wlc=0 \
    wwc=0 wwlc=0 dwg=-1.33E-8 dwb=-1.08E-8 \
    xl=0 xw=0 dmcg=0 dmdg=0 \
    dmcgt=0 xgw=0 xgl=0 ngcon=1 \
    vth0=0.249959346666667 lvth0=-1.985141612666671E-9 vfb=0 k1=1.011211866666667 \
    lk1=-4.876429660666666E-8 k2=-0.21737859252 lk2=1.7355223637994E-8 k3=1.65 \
    k3b=1.6 w0=1E-7 lpe0=2.3802E-7 lpeb=-4.9152E-8 \
    vbm=-3 dvtp0=0 dvtp1=0 dvt0=0.07665 \
    dvt1=0.1252 dvt2=-0.05637 dvt0w=0 dvt1w=5.3E6 \
    dvt2w=-0.032 vfbsdoff=0 u0=0.01421071555 lu0=2.166698264775001E-10 \
    ua=-3.496851672833332E-9 lua=1.729222681883582E-16 ub=4.57941585E-18 lub=-2.719028563075E-25 \
    uc=1.863698448333334E-10 luc=-2.261771620175834E-17 ud=0 up=0 \
    lp=1 eu=1.67 vsat=1.819855189500001E5 lvsat=-1.786254255252507E-3 \
    a0=0 ags=1.005218833333333 lags=3.096873294166675E-8 b0=0 \
    b1=0 keta=0.1569286063 lketa=-4.276737497598501E-8 a1=0 \
    a2=0.38689047 rdsw=103.65 rdswmin=0 rdw=0 \
    rdwmin=0 rsw=0 rswmin=0 prwb=0 \
    prwg=0 wr=1 voff=-0.11934831869 lvoff=5.296050099455504E-9 \
    voffl=0 minv=0 nfactor=0.723459400166666 lnfactor=3.583940752490084E-7 \
    eta0=0.067637351756667 leta0=1.529144370447834E-9 etab=-0.077077273825 letab=9.70788263825875E-9 \
    dsub=0.58180516425 ldsub=-4.053136043728748E-8 cit=5E-6 cdsc=3.8556E-37 \
    cdscb=-1.1484E-4 cdscd=4.7984E-6 pclm=0.086824416666667 lpclm=9.59179572083335E-9 \
    pdiblc1=3.583688213883334 lpdiblc1=-4.029261769551058E-7 pdiblc2=0.064735802833333 lpdiblc2=-7.957785851858334E-9 \
    pdiblcb=0 drout=3.4946 pscbe1=4.5E8 pscbe2=1E-8 \
    pvag=0 delta=0.01 fprout=0 pdits=1.4427E-15 \
    pditsl=0 pditsd=0 lambda=0 vtl=0 \
    lc=0 xn=0 alpha0=1.687407635666667E-3 lalpha0=-1.627859334572167E-10 \
    alpha1=0 beta0=31.24083182666667 lbeta0=-3.496153888186668E-7 aigbacc=1 \
    bigbacc=0 cigbacc=0 nigbacc=1 aigbinv=0.35 \
    bigbinv=0.03 cigbinv=6E-3 eigbinv=1.1 nigbinv=3 \
    aigc=0.43 bigc=0.054 cigc=0.075 aigsd=0.43 \
    bigsd=0.054 cigsd=0.075 dlcig=0 nigc=1 \
    poxedge=1 pigcd=1 ntox=1 toxref=4.148E-9 \
    agidl=0 bgidl=2.3E9 cgidl=0.5 egidl=0.8 \
    noia=9E41 noib=1E27 noic=8E11 em=4.1E7 \
    af=1 ef=1.2 kf=0 lintnoi=-3E-7 \
    tnoia=2.5E7 tnoib=9.9E6 ntnoi=1 rnoia=0.912 \
    rnoib=0.26 xpart=0 cgso=2.392894381e-10 cgdo=2.392894381e-10 \
    cgbo=1e-14 ckappas=0.6 cf=1E-14 clc=1E-7 \
    cle=0.6 dlc=1.21071E-8 dwc=2.6E-8 vfbcv=-1 \
    noff=3.8661 voffcv=-0.16994 acde=0.38008 moin=23.81 \
    cgsl=2.310725e-11 cgdl=2.310725e-11 ijthsrev=0.1 ijthsfwd=0.1 \
    xjbvs=1 bvs=11.9 jss=2.75E-3 jsws=6E-10 \
    cjs=0.00121 mjs=0.42197 mjsws=1E-3 cjsws=3.230311424e-11 \
    cjswgs=1.795291232e-10 mjswgs=0.8 pbs=0.7477 pbsws=0.1 \
    pbswgs=0.79644 xrcrg1=12 xrcrg2=1 rbpb=50 \
    rbpd=50 rbps=50 rbdb=50 rbsb=50 \
    gbmin=1E-12 tnom=30 ute=-2.841387833333333 lute=1.462012276083332E-7 \
    kt1=-0.295119316666667 lkt1=-2.874265065833337E-9 kt1l=0 kt2=0.02122778 \
    lkt2=-5.743292291000001E-9 ua1=-2.42902207E-9 lua1=3.816539507165E-16 ub1=2.4443796E-18 \
    lub1=-4.0006627012E-25 uc1=5.2148775E-12 luc1=-5.195283211249999E-19 at=6.394335E4 \
    lat=2.4945216175E-3 prt=0 njs=1.2928 xtis=2 \
    tpb=1.2287E-3 tpbsw=0 tpbswg=0 tcj=7.92E-4 \
    tcjsw=1E-5 tcjswg=0 tvoff=0 tvfbsdoff=0 \
    saref=1.1E-6 sbref=1.1E-6 wlod=0 ku0=-2.7E-8 \
    kvsat=0.2 kvth0=7.9E-9 tku0=0 llodku0=0 \
    wlodku0=1 llodvth=0 wlodvth=1 lku0=0 \
    wku0=0 pku0=0 lkvth0=0 wkvth0=3E-7 \
    pkvth0=0 stk2=0 lodk2=1 steta0=0 \
    lodeta0=1 rsh=493.9815864022663

// l=0.15 w=35.3 nf=22 -> bin nlowvt_model.8  rsh=499.0297 delvto=0 (folded into vth0)
model nlowvt_model__w35p3nf22 bsim4 \
    type=n version=4.50 binunit=2 mobmod=0 \
    capmod=2 rdsmod=0 igcmod=0 igbmod=0 \
    rbodymod=1 trnqsmod=0 acnqsmod=0 fnoimod=1 \
    tnoimod=1 diomod=1 tempmod=0 permod=1 \
    geomod=0 rgatemod=0 epsrox=3.9 toxe=4.148E-9 \
    toxm=4.148E-9 dtox=0 xj=1.5E-7 ndep=1.7E17 \
    ngate=9.999999999999999E22 nsd=1E20 rshg=0.1 phin=0 \
    wint=2.6e-08 wl=0 wln=1 ww=0 \
    wwn=1 wwl=0 lint=1.2025e-08 ll=0 \
    lln=1 lw=0 lwn=1 lwl=0 \
    llc=0 lwc=0 lwlc=0 wlc=0 \
    wwc=0 wwlc=0 dwg=-1.33E-8 dwb=-1.08E-8 \
    xl=0 xw=0 dmcg=0 dmdg=0 \
    dmcgt=0 xgw=0 xgl=0 ngcon=1 \
    vth0=0.249959346666667 lvth0=-1.985141612666671E-9 vfb=0 k1=1.011211866666667 \
    lk1=-4.876429660666666E-8 k2=-0.21737859252 lk2=1.7355223637994E-8 k3=1.65 \
    k3b=1.6 w0=1E-7 lpe0=2.3802E-7 lpeb=-4.9152E-8 \
    vbm=-3 dvtp0=0 dvtp1=0 dvt0=0.07665 \
    dvt1=0.1252 dvt2=-0.05637 dvt0w=0 dvt1w=5.3E6 \
    dvt2w=-0.032 vfbsdoff=0 u0=0.01421071555 lu0=2.166698264775001E-10 \
    ua=-3.496851672833332E-9 lua=1.729222681883582E-16 ub=4.57941585E-18 lub=-2.719028563075E-25 \
    uc=1.863698448333334E-10 luc=-2.261771620175834E-17 ud=0 up=0 \
    lp=1 eu=1.67 vsat=1.819855189500001E5 lvsat=-1.786254255252507E-3 \
    a0=0 ags=1.005218833333333 lags=3.096873294166675E-8 b0=0 \
    b1=0 keta=0.1569286063 lketa=-4.276737497598501E-8 a1=0 \
    a2=0.38689047 rdsw=103.65 rdswmin=0 rdw=0 \
    rdwmin=0 rsw=0 rswmin=0 prwb=0 \
    prwg=0 wr=1 voff=-0.11934831869 lvoff=5.296050099455504E-9 \
    voffl=0 minv=0 nfactor=0.723459400166666 lnfactor=3.583940752490084E-7 \
    eta0=0.067637351756667 leta0=1.529144370447834E-9 etab=-0.077077273825 letab=9.70788263825875E-9 \
    dsub=0.58180516425 ldsub=-4.053136043728748E-8 cit=5E-6 cdsc=3.8556E-37 \
    cdscb=-1.1484E-4 cdscd=4.7984E-6 pclm=0.086824416666667 lpclm=9.59179572083335E-9 \
    pdiblc1=3.583688213883334 lpdiblc1=-4.029261769551058E-7 pdiblc2=0.064735802833333 lpdiblc2=-7.957785851858334E-9 \
    pdiblcb=0 drout=3.4946 pscbe1=4.5E8 pscbe2=1E-8 \
    pvag=0 delta=0.01 fprout=0 pdits=1.4427E-15 \
    pditsl=0 pditsd=0 lambda=0 vtl=0 \
    lc=0 xn=0 alpha0=1.687407635666667E-3 lalpha0=-1.627859334572167E-10 \
    alpha1=0 beta0=31.24083182666667 lbeta0=-3.496153888186668E-7 aigbacc=1 \
    bigbacc=0 cigbacc=0 nigbacc=1 aigbinv=0.35 \
    bigbinv=0.03 cigbinv=6E-3 eigbinv=1.1 nigbinv=3 \
    aigc=0.43 bigc=0.054 cigc=0.075 aigsd=0.43 \
    bigsd=0.054 cigsd=0.075 dlcig=0 nigc=1 \
    poxedge=1 pigcd=1 ntox=1 toxref=4.148E-9 \
    agidl=0 bgidl=2.3E9 cgidl=0.5 egidl=0.8 \
    noia=9E41 noib=1E27 noic=8E11 em=4.1E7 \
    af=1 ef=1.2 kf=0 lintnoi=-3E-7 \
    tnoia=2.5E7 tnoib=9.9E6 ntnoi=1 rnoia=0.912 \
    rnoib=0.26 xpart=0 cgso=2.392894381e-10 cgdo=2.392894381e-10 \
    cgbo=1e-14 ckappas=0.6 cf=1E-14 clc=1E-7 \
    cle=0.6 dlc=1.21071E-8 dwc=2.6E-8 vfbcv=-1 \
    noff=3.8661 voffcv=-0.16994 acde=0.38008 moin=23.81 \
    cgsl=2.310725e-11 cgdl=2.310725e-11 ijthsrev=0.1 ijthsfwd=0.1 \
    xjbvs=1 bvs=11.9 jss=2.75E-3 jsws=6E-10 \
    cjs=0.00121 mjs=0.42197 mjsws=1E-3 cjsws=3.230311424e-11 \
    cjswgs=1.795291232e-10 mjswgs=0.8 pbs=0.7477 pbsws=0.1 \
    pbswgs=0.79644 xrcrg1=12 xrcrg2=1 rbpb=50 \
    rbpd=50 rbps=50 rbdb=50 rbsb=50 \
    gbmin=1E-12 tnom=30 ute=-2.841387833333333 lute=1.462012276083332E-7 \
    kt1=-0.295119316666667 lkt1=-2.874265065833337E-9 kt1l=0 kt2=0.02122778 \
    lkt2=-5.743292291000001E-9 ua1=-2.42902207E-9 lua1=3.816539507165E-16 ub1=2.4443796E-18 \
    lub1=-4.0006627012E-25 uc1=5.2148775E-12 luc1=-5.195283211249999E-19 at=6.394335E4 \
    lat=2.4945216175E-3 prt=0 njs=1.2928 xtis=2 \
    tpb=1.2287E-3 tpbsw=0 tpbswg=0 tcj=7.92E-4 \
    tcjsw=1E-5 tcjswg=0 tvoff=0 tvfbsdoff=0 \
    saref=1.1E-6 sbref=1.1E-6 wlod=0 ku0=-2.7E-8 \
    kvsat=0.2 kvth0=7.9E-9 tku0=0 llodku0=0 \
    wlodku0=1 llodvth=0 wlodvth=1 lku0=0 \
    wku0=0 pku0=0 lkvth0=0 wkvth0=3E-7 \
    pkvth0=0 stk2=0 lodk2=1 steta0=0 \
    lodeta0=1 rsh=499.0297450424929

// l=0.15 w=35.3 nf=24 -> bin nlowvt_model.8  rsh=504.0779 delvto=0 (folded into vth0)
model nlowvt_model__w35p3nf24 bsim4 \
    type=n version=4.50 binunit=2 mobmod=0 \
    capmod=2 rdsmod=0 igcmod=0 igbmod=0 \
    rbodymod=1 trnqsmod=0 acnqsmod=0 fnoimod=1 \
    tnoimod=1 diomod=1 tempmod=0 permod=1 \
    geomod=0 rgatemod=0 epsrox=3.9 toxe=4.148E-9 \
    toxm=4.148E-9 dtox=0 xj=1.5E-7 ndep=1.7E17 \
    ngate=9.999999999999999E22 nsd=1E20 rshg=0.1 phin=0 \
    wint=2.6e-08 wl=0 wln=1 ww=0 \
    wwn=1 wwl=0 lint=1.2025e-08 ll=0 \
    lln=1 lw=0 lwn=1 lwl=0 \
    llc=0 lwc=0 lwlc=0 wlc=0 \
    wwc=0 wwlc=0 dwg=-1.33E-8 dwb=-1.08E-8 \
    xl=0 xw=0 dmcg=0 dmdg=0 \
    dmcgt=0 xgw=0 xgl=0 ngcon=1 \
    vth0=0.249959346666667 lvth0=-1.985141612666671E-9 vfb=0 k1=1.011211866666667 \
    lk1=-4.876429660666666E-8 k2=-0.21737859252 lk2=1.7355223637994E-8 k3=1.65 \
    k3b=1.6 w0=1E-7 lpe0=2.3802E-7 lpeb=-4.9152E-8 \
    vbm=-3 dvtp0=0 dvtp1=0 dvt0=0.07665 \
    dvt1=0.1252 dvt2=-0.05637 dvt0w=0 dvt1w=5.3E6 \
    dvt2w=-0.032 vfbsdoff=0 u0=0.01421071555 lu0=2.166698264775001E-10 \
    ua=-3.496851672833332E-9 lua=1.729222681883582E-16 ub=4.57941585E-18 lub=-2.719028563075E-25 \
    uc=1.863698448333334E-10 luc=-2.261771620175834E-17 ud=0 up=0 \
    lp=1 eu=1.67 vsat=1.819855189500001E5 lvsat=-1.786254255252507E-3 \
    a0=0 ags=1.005218833333333 lags=3.096873294166675E-8 b0=0 \
    b1=0 keta=0.1569286063 lketa=-4.276737497598501E-8 a1=0 \
    a2=0.38689047 rdsw=103.65 rdswmin=0 rdw=0 \
    rdwmin=0 rsw=0 rswmin=0 prwb=0 \
    prwg=0 wr=1 voff=-0.11934831869 lvoff=5.296050099455504E-9 \
    voffl=0 minv=0 nfactor=0.723459400166666 lnfactor=3.583940752490084E-7 \
    eta0=0.067637351756667 leta0=1.529144370447834E-9 etab=-0.077077273825 letab=9.70788263825875E-9 \
    dsub=0.58180516425 ldsub=-4.053136043728748E-8 cit=5E-6 cdsc=3.8556E-37 \
    cdscb=-1.1484E-4 cdscd=4.7984E-6 pclm=0.086824416666667 lpclm=9.59179572083335E-9 \
    pdiblc1=3.583688213883334 lpdiblc1=-4.029261769551058E-7 pdiblc2=0.064735802833333 lpdiblc2=-7.957785851858334E-9 \
    pdiblcb=0 drout=3.4946 pscbe1=4.5E8 pscbe2=1E-8 \
    pvag=0 delta=0.01 fprout=0 pdits=1.4427E-15 \
    pditsl=0 pditsd=0 lambda=0 vtl=0 \
    lc=0 xn=0 alpha0=1.687407635666667E-3 lalpha0=-1.627859334572167E-10 \
    alpha1=0 beta0=31.24083182666667 lbeta0=-3.496153888186668E-7 aigbacc=1 \
    bigbacc=0 cigbacc=0 nigbacc=1 aigbinv=0.35 \
    bigbinv=0.03 cigbinv=6E-3 eigbinv=1.1 nigbinv=3 \
    aigc=0.43 bigc=0.054 cigc=0.075 aigsd=0.43 \
    bigsd=0.054 cigsd=0.075 dlcig=0 nigc=1 \
    poxedge=1 pigcd=1 ntox=1 toxref=4.148E-9 \
    agidl=0 bgidl=2.3E9 cgidl=0.5 egidl=0.8 \
    noia=9E41 noib=1E27 noic=8E11 em=4.1E7 \
    af=1 ef=1.2 kf=0 lintnoi=-3E-7 \
    tnoia=2.5E7 tnoib=9.9E6 ntnoi=1 rnoia=0.912 \
    rnoib=0.26 xpart=0 cgso=2.392894381e-10 cgdo=2.392894381e-10 \
    cgbo=1e-14 ckappas=0.6 cf=1E-14 clc=1E-7 \
    cle=0.6 dlc=1.21071E-8 dwc=2.6E-8 vfbcv=-1 \
    noff=3.8661 voffcv=-0.16994 acde=0.38008 moin=23.81 \
    cgsl=2.310725e-11 cgdl=2.310725e-11 ijthsrev=0.1 ijthsfwd=0.1 \
    xjbvs=1 bvs=11.9 jss=2.75E-3 jsws=6E-10 \
    cjs=0.00121 mjs=0.42197 mjsws=1E-3 cjsws=3.230311424e-11 \
    cjswgs=1.795291232e-10 mjswgs=0.8 pbs=0.7477 pbsws=0.1 \
    pbswgs=0.79644 xrcrg1=12 xrcrg2=1 rbpb=50 \
    rbpd=50 rbps=50 rbdb=50 rbsb=50 \
    gbmin=1E-12 tnom=30 ute=-2.841387833333333 lute=1.462012276083332E-7 \
    kt1=-0.295119316666667 lkt1=-2.874265065833337E-9 kt1l=0 kt2=0.02122778 \
    lkt2=-5.743292291000001E-9 ua1=-2.42902207E-9 lua1=3.816539507165E-16 ub1=2.4443796E-18 \
    lub1=-4.0006627012E-25 uc1=5.2148775E-12 luc1=-5.195283211249999E-19 at=6.394335E4 \
    lat=2.4945216175E-3 prt=0 njs=1.2928 xtis=2 \
    tpb=1.2287E-3 tpbsw=0 tpbswg=0 tcj=7.92E-4 \
    tcjsw=1E-5 tcjswg=0 tvoff=0 tvfbsdoff=0 \
    saref=1.1E-6 sbref=1.1E-6 wlod=0 ku0=-2.7E-8 \
    kvsat=0.2 kvth0=7.9E-9 tku0=0 llodku0=0 \
    wlodku0=1 llodvth=0 wlodvth=1 lku0=0 \
    wku0=0 pku0=0 lkvth0=0 wkvth0=3E-7 \
    pkvth0=0 stk2=0 lodk2=1 steta0=0 \
    lodeta0=1 rsh=504.0779036827195

// l=0.15 w=35.3 nf=26 -> bin nlowvt_model.8  rsh=509.1261 delvto=0 (folded into vth0)
model nlowvt_model__w35p3nf26 bsim4 \
    type=n version=4.50 binunit=2 mobmod=0 \
    capmod=2 rdsmod=0 igcmod=0 igbmod=0 \
    rbodymod=1 trnqsmod=0 acnqsmod=0 fnoimod=1 \
    tnoimod=1 diomod=1 tempmod=0 permod=1 \
    geomod=0 rgatemod=0 epsrox=3.9 toxe=4.148E-9 \
    toxm=4.148E-9 dtox=0 xj=1.5E-7 ndep=1.7E17 \
    ngate=9.999999999999999E22 nsd=1E20 rshg=0.1 phin=0 \
    wint=2.6e-08 wl=0 wln=1 ww=0 \
    wwn=1 wwl=0 lint=1.2025e-08 ll=0 \
    lln=1 lw=0 lwn=1 lwl=0 \
    llc=0 lwc=0 lwlc=0 wlc=0 \
    wwc=0 wwlc=0 dwg=-1.33E-8 dwb=-1.08E-8 \
    xl=0 xw=0 dmcg=0 dmdg=0 \
    dmcgt=0 xgw=0 xgl=0 ngcon=1 \
    vth0=0.249959346666667 lvth0=-1.985141612666671E-9 vfb=0 k1=1.011211866666667 \
    lk1=-4.876429660666666E-8 k2=-0.21737859252 lk2=1.7355223637994E-8 k3=1.65 \
    k3b=1.6 w0=1E-7 lpe0=2.3802E-7 lpeb=-4.9152E-8 \
    vbm=-3 dvtp0=0 dvtp1=0 dvt0=0.07665 \
    dvt1=0.1252 dvt2=-0.05637 dvt0w=0 dvt1w=5.3E6 \
    dvt2w=-0.032 vfbsdoff=0 u0=0.01421071555 lu0=2.166698264775001E-10 \
    ua=-3.496851672833332E-9 lua=1.729222681883582E-16 ub=4.57941585E-18 lub=-2.719028563075E-25 \
    uc=1.863698448333334E-10 luc=-2.261771620175834E-17 ud=0 up=0 \
    lp=1 eu=1.67 vsat=1.819855189500001E5 lvsat=-1.786254255252507E-3 \
    a0=0 ags=1.005218833333333 lags=3.096873294166675E-8 b0=0 \
    b1=0 keta=0.1569286063 lketa=-4.276737497598501E-8 a1=0 \
    a2=0.38689047 rdsw=103.65 rdswmin=0 rdw=0 \
    rdwmin=0 rsw=0 rswmin=0 prwb=0 \
    prwg=0 wr=1 voff=-0.11934831869 lvoff=5.296050099455504E-9 \
    voffl=0 minv=0 nfactor=0.723459400166666 lnfactor=3.583940752490084E-7 \
    eta0=0.067637351756667 leta0=1.529144370447834E-9 etab=-0.077077273825 letab=9.70788263825875E-9 \
    dsub=0.58180516425 ldsub=-4.053136043728748E-8 cit=5E-6 cdsc=3.8556E-37 \
    cdscb=-1.1484E-4 cdscd=4.7984E-6 pclm=0.086824416666667 lpclm=9.59179572083335E-9 \
    pdiblc1=3.583688213883334 lpdiblc1=-4.029261769551058E-7 pdiblc2=0.064735802833333 lpdiblc2=-7.957785851858334E-9 \
    pdiblcb=0 drout=3.4946 pscbe1=4.5E8 pscbe2=1E-8 \
    pvag=0 delta=0.01 fprout=0 pdits=1.4427E-15 \
    pditsl=0 pditsd=0 lambda=0 vtl=0 \
    lc=0 xn=0 alpha0=1.687407635666667E-3 lalpha0=-1.627859334572167E-10 \
    alpha1=0 beta0=31.24083182666667 lbeta0=-3.496153888186668E-7 aigbacc=1 \
    bigbacc=0 cigbacc=0 nigbacc=1 aigbinv=0.35 \
    bigbinv=0.03 cigbinv=6E-3 eigbinv=1.1 nigbinv=3 \
    aigc=0.43 bigc=0.054 cigc=0.075 aigsd=0.43 \
    bigsd=0.054 cigsd=0.075 dlcig=0 nigc=1 \
    poxedge=1 pigcd=1 ntox=1 toxref=4.148E-9 \
    agidl=0 bgidl=2.3E9 cgidl=0.5 egidl=0.8 \
    noia=9E41 noib=1E27 noic=8E11 em=4.1E7 \
    af=1 ef=1.2 kf=0 lintnoi=-3E-7 \
    tnoia=2.5E7 tnoib=9.9E6 ntnoi=1 rnoia=0.912 \
    rnoib=0.26 xpart=0 cgso=2.392894381e-10 cgdo=2.392894381e-10 \
    cgbo=1e-14 ckappas=0.6 cf=1E-14 clc=1E-7 \
    cle=0.6 dlc=1.21071E-8 dwc=2.6E-8 vfbcv=-1 \
    noff=3.8661 voffcv=-0.16994 acde=0.38008 moin=23.81 \
    cgsl=2.310725e-11 cgdl=2.310725e-11 ijthsrev=0.1 ijthsfwd=0.1 \
    xjbvs=1 bvs=11.9 jss=2.75E-3 jsws=6E-10 \
    cjs=0.00121 mjs=0.42197 mjsws=1E-3 cjsws=3.230311424e-11 \
    cjswgs=1.795291232e-10 mjswgs=0.8 pbs=0.7477 pbsws=0.1 \
    pbswgs=0.79644 xrcrg1=12 xrcrg2=1 rbpb=50 \
    rbpd=50 rbps=50 rbdb=50 rbsb=50 \
    gbmin=1E-12 tnom=30 ute=-2.841387833333333 lute=1.462012276083332E-7 \
    kt1=-0.295119316666667 lkt1=-2.874265065833337E-9 kt1l=0 kt2=0.02122778 \
    lkt2=-5.743292291000001E-9 ua1=-2.42902207E-9 lua1=3.816539507165E-16 ub1=2.4443796E-18 \
    lub1=-4.0006627012E-25 uc1=5.2148775E-12 luc1=-5.195283211249999E-19 at=6.394335E4 \
    lat=2.4945216175E-3 prt=0 njs=1.2928 xtis=2 \
    tpb=1.2287E-3 tpbsw=0 tpbswg=0 tcj=7.92E-4 \
    tcjsw=1E-5 tcjswg=0 tvoff=0 tvfbsdoff=0 \
    saref=1.1E-6 sbref=1.1E-6 wlod=0 ku0=-2.7E-8 \
    kvsat=0.2 kvth0=7.9E-9 tku0=0 llodku0=0 \
    wlodku0=1 llodvth=0 wlodvth=1 lku0=0 \
    wku0=0 pku0=0 lkvth0=0 wkvth0=3E-7 \
    pkvth0=0 stk2=0 lodk2=1 steta0=0 \
    lodeta0=1 rsh=509.12606232294615

// l=0.15 w=39.3 nf=18 -> bin nlowvt_model.8  rsh=484.3092 delvto=0 (folded into vth0)
model nlowvt_model__w39p3nf18 bsim4 \
    type=n version=4.50 binunit=2 mobmod=0 \
    capmod=2 rdsmod=0 igcmod=0 igbmod=0 \
    rbodymod=1 trnqsmod=0 acnqsmod=0 fnoimod=1 \
    tnoimod=1 diomod=1 tempmod=0 permod=1 \
    geomod=0 rgatemod=0 epsrox=3.9 toxe=4.148E-9 \
    toxm=4.148E-9 dtox=0 xj=1.5E-7 ndep=1.7E17 \
    ngate=9.999999999999999E22 nsd=1E20 rshg=0.1 phin=0 \
    wint=2.6e-08 wl=0 wln=1 ww=0 \
    wwn=1 wwl=0 lint=1.2025e-08 ll=0 \
    lln=1 lw=0 lwn=1 lwl=0 \
    llc=0 lwc=0 lwlc=0 wlc=0 \
    wwc=0 wwlc=0 dwg=-1.33E-8 dwb=-1.08E-8 \
    xl=0 xw=0 dmcg=0 dmdg=0 \
    dmcgt=0 xgw=0 xgl=0 ngcon=1 \
    vth0=0.249959346666667 lvth0=-1.985141612666671E-9 vfb=0 k1=1.011211866666667 \
    lk1=-4.876429660666666E-8 k2=-0.21737859252 lk2=1.7355223637994E-8 k3=1.65 \
    k3b=1.6 w0=1E-7 lpe0=2.3802E-7 lpeb=-4.9152E-8 \
    vbm=-3 dvtp0=0 dvtp1=0 dvt0=0.07665 \
    dvt1=0.1252 dvt2=-0.05637 dvt0w=0 dvt1w=5.3E6 \
    dvt2w=-0.032 vfbsdoff=0 u0=0.01421071555 lu0=2.166698264775001E-10 \
    ua=-3.496851672833332E-9 lua=1.729222681883582E-16 ub=4.57941585E-18 lub=-2.719028563075E-25 \
    uc=1.863698448333334E-10 luc=-2.261771620175834E-17 ud=0 up=0 \
    lp=1 eu=1.67 vsat=1.819855189500001E5 lvsat=-1.786254255252507E-3 \
    a0=0 ags=1.005218833333333 lags=3.096873294166675E-8 b0=0 \
    b1=0 keta=0.1569286063 lketa=-4.276737497598501E-8 a1=0 \
    a2=0.38689047 rdsw=103.65 rdswmin=0 rdw=0 \
    rdwmin=0 rsw=0 rswmin=0 prwb=0 \
    prwg=0 wr=1 voff=-0.11934831869 lvoff=5.296050099455504E-9 \
    voffl=0 minv=0 nfactor=0.723459400166666 lnfactor=3.583940752490084E-7 \
    eta0=0.067637351756667 leta0=1.529144370447834E-9 etab=-0.077077273825 letab=9.70788263825875E-9 \
    dsub=0.58180516425 ldsub=-4.053136043728748E-8 cit=5E-6 cdsc=3.8556E-37 \
    cdscb=-1.1484E-4 cdscd=4.7984E-6 pclm=0.086824416666667 lpclm=9.59179572083335E-9 \
    pdiblc1=3.583688213883334 lpdiblc1=-4.029261769551058E-7 pdiblc2=0.064735802833333 lpdiblc2=-7.957785851858334E-9 \
    pdiblcb=0 drout=3.4946 pscbe1=4.5E8 pscbe2=1E-8 \
    pvag=0 delta=0.01 fprout=0 pdits=1.4427E-15 \
    pditsl=0 pditsd=0 lambda=0 vtl=0 \
    lc=0 xn=0 alpha0=1.687407635666667E-3 lalpha0=-1.627859334572167E-10 \
    alpha1=0 beta0=31.24083182666667 lbeta0=-3.496153888186668E-7 aigbacc=1 \
    bigbacc=0 cigbacc=0 nigbacc=1 aigbinv=0.35 \
    bigbinv=0.03 cigbinv=6E-3 eigbinv=1.1 nigbinv=3 \
    aigc=0.43 bigc=0.054 cigc=0.075 aigsd=0.43 \
    bigsd=0.054 cigsd=0.075 dlcig=0 nigc=1 \
    poxedge=1 pigcd=1 ntox=1 toxref=4.148E-9 \
    agidl=0 bgidl=2.3E9 cgidl=0.5 egidl=0.8 \
    noia=9E41 noib=1E27 noic=8E11 em=4.1E7 \
    af=1 ef=1.2 kf=0 lintnoi=-3E-7 \
    tnoia=2.5E7 tnoib=9.9E6 ntnoi=1 rnoia=0.912 \
    rnoib=0.26 xpart=0 cgso=2.392894381e-10 cgdo=2.392894381e-10 \
    cgbo=1e-14 ckappas=0.6 cf=1E-14 clc=1E-7 \
    cle=0.6 dlc=1.21071E-8 dwc=2.6E-8 vfbcv=-1 \
    noff=3.8661 voffcv=-0.16994 acde=0.38008 moin=23.81 \
    cgsl=2.310725e-11 cgdl=2.310725e-11 ijthsrev=0.1 ijthsfwd=0.1 \
    xjbvs=1 bvs=11.9 jss=2.75E-3 jsws=6E-10 \
    cjs=0.00121 mjs=0.42197 mjsws=1E-3 cjsws=3.230311424e-11 \
    cjswgs=1.795291232e-10 mjswgs=0.8 pbs=0.7477 pbsws=0.1 \
    pbswgs=0.79644 xrcrg1=12 xrcrg2=1 rbpb=50 \
    rbpd=50 rbps=50 rbdb=50 rbsb=50 \
    gbmin=1E-12 tnom=30 ute=-2.841387833333333 lute=1.462012276083332E-7 \
    kt1=-0.295119316666667 lkt1=-2.874265065833337E-9 kt1l=0 kt2=0.02122778 \
    lkt2=-5.743292291000001E-9 ua1=-2.42902207E-9 lua1=3.816539507165E-16 ub1=2.4443796E-18 \
    lub1=-4.0006627012E-25 uc1=5.2148775E-12 luc1=-5.195283211249999E-19 at=6.394335E4 \
    lat=2.4945216175E-3 prt=0 njs=1.2928 xtis=2 \
    tpb=1.2287E-3 tpbsw=0 tpbswg=0 tcj=7.92E-4 \
    tcjsw=1E-5 tcjswg=0 tvoff=0 tvfbsdoff=0 \
    saref=1.1E-6 sbref=1.1E-6 wlod=0 ku0=-2.7E-8 \
    kvsat=0.2 kvth0=7.9E-9 tku0=0 llodku0=0 \
    wlodku0=1 llodvth=0 wlodvth=1 lku0=0 \
    wku0=0 pku0=0 lkvth0=0 wkvth0=3E-7 \
    pkvth0=0 stk2=0 lodk2=1 steta0=0 \
    lodeta0=1 rsh=484.30916030534354

// l=0.15 w=39.3 nf=20 -> bin nlowvt_model.8  rsh=488.8435 delvto=0 (folded into vth0)
model nlowvt_model__w39p3nf20 bsim4 \
    type=n version=4.50 binunit=2 mobmod=0 \
    capmod=2 rdsmod=0 igcmod=0 igbmod=0 \
    rbodymod=1 trnqsmod=0 acnqsmod=0 fnoimod=1 \
    tnoimod=1 diomod=1 tempmod=0 permod=1 \
    geomod=0 rgatemod=0 epsrox=3.9 toxe=4.148E-9 \
    toxm=4.148E-9 dtox=0 xj=1.5E-7 ndep=1.7E17 \
    ngate=9.999999999999999E22 nsd=1E20 rshg=0.1 phin=0 \
    wint=2.6e-08 wl=0 wln=1 ww=0 \
    wwn=1 wwl=0 lint=1.2025e-08 ll=0 \
    lln=1 lw=0 lwn=1 lwl=0 \
    llc=0 lwc=0 lwlc=0 wlc=0 \
    wwc=0 wwlc=0 dwg=-1.33E-8 dwb=-1.08E-8 \
    xl=0 xw=0 dmcg=0 dmdg=0 \
    dmcgt=0 xgw=0 xgl=0 ngcon=1 \
    vth0=0.249959346666667 lvth0=-1.985141612666671E-9 vfb=0 k1=1.011211866666667 \
    lk1=-4.876429660666666E-8 k2=-0.21737859252 lk2=1.7355223637994E-8 k3=1.65 \
    k3b=1.6 w0=1E-7 lpe0=2.3802E-7 lpeb=-4.9152E-8 \
    vbm=-3 dvtp0=0 dvtp1=0 dvt0=0.07665 \
    dvt1=0.1252 dvt2=-0.05637 dvt0w=0 dvt1w=5.3E6 \
    dvt2w=-0.032 vfbsdoff=0 u0=0.01421071555 lu0=2.166698264775001E-10 \
    ua=-3.496851672833332E-9 lua=1.729222681883582E-16 ub=4.57941585E-18 lub=-2.719028563075E-25 \
    uc=1.863698448333334E-10 luc=-2.261771620175834E-17 ud=0 up=0 \
    lp=1 eu=1.67 vsat=1.819855189500001E5 lvsat=-1.786254255252507E-3 \
    a0=0 ags=1.005218833333333 lags=3.096873294166675E-8 b0=0 \
    b1=0 keta=0.1569286063 lketa=-4.276737497598501E-8 a1=0 \
    a2=0.38689047 rdsw=103.65 rdswmin=0 rdw=0 \
    rdwmin=0 rsw=0 rswmin=0 prwb=0 \
    prwg=0 wr=1 voff=-0.11934831869 lvoff=5.296050099455504E-9 \
    voffl=0 minv=0 nfactor=0.723459400166666 lnfactor=3.583940752490084E-7 \
    eta0=0.067637351756667 leta0=1.529144370447834E-9 etab=-0.077077273825 letab=9.70788263825875E-9 \
    dsub=0.58180516425 ldsub=-4.053136043728748E-8 cit=5E-6 cdsc=3.8556E-37 \
    cdscb=-1.1484E-4 cdscd=4.7984E-6 pclm=0.086824416666667 lpclm=9.59179572083335E-9 \
    pdiblc1=3.583688213883334 lpdiblc1=-4.029261769551058E-7 pdiblc2=0.064735802833333 lpdiblc2=-7.957785851858334E-9 \
    pdiblcb=0 drout=3.4946 pscbe1=4.5E8 pscbe2=1E-8 \
    pvag=0 delta=0.01 fprout=0 pdits=1.4427E-15 \
    pditsl=0 pditsd=0 lambda=0 vtl=0 \
    lc=0 xn=0 alpha0=1.687407635666667E-3 lalpha0=-1.627859334572167E-10 \
    alpha1=0 beta0=31.24083182666667 lbeta0=-3.496153888186668E-7 aigbacc=1 \
    bigbacc=0 cigbacc=0 nigbacc=1 aigbinv=0.35 \
    bigbinv=0.03 cigbinv=6E-3 eigbinv=1.1 nigbinv=3 \
    aigc=0.43 bigc=0.054 cigc=0.075 aigsd=0.43 \
    bigsd=0.054 cigsd=0.075 dlcig=0 nigc=1 \
    poxedge=1 pigcd=1 ntox=1 toxref=4.148E-9 \
    agidl=0 bgidl=2.3E9 cgidl=0.5 egidl=0.8 \
    noia=9E41 noib=1E27 noic=8E11 em=4.1E7 \
    af=1 ef=1.2 kf=0 lintnoi=-3E-7 \
    tnoia=2.5E7 tnoib=9.9E6 ntnoi=1 rnoia=0.912 \
    rnoib=0.26 xpart=0 cgso=2.392894381e-10 cgdo=2.392894381e-10 \
    cgbo=1e-14 ckappas=0.6 cf=1E-14 clc=1E-7 \
    cle=0.6 dlc=1.21071E-8 dwc=2.6E-8 vfbcv=-1 \
    noff=3.8661 voffcv=-0.16994 acde=0.38008 moin=23.81 \
    cgsl=2.310725e-11 cgdl=2.310725e-11 ijthsrev=0.1 ijthsfwd=0.1 \
    xjbvs=1 bvs=11.9 jss=2.75E-3 jsws=6E-10 \
    cjs=0.00121 mjs=0.42197 mjsws=1E-3 cjsws=3.230311424e-11 \
    cjswgs=1.795291232e-10 mjswgs=0.8 pbs=0.7477 pbsws=0.1 \
    pbswgs=0.79644 xrcrg1=12 xrcrg2=1 rbpb=50 \
    rbpd=50 rbps=50 rbdb=50 rbsb=50 \
    gbmin=1E-12 tnom=30 ute=-2.841387833333333 lute=1.462012276083332E-7 \
    kt1=-0.295119316666667 lkt1=-2.874265065833337E-9 kt1l=0 kt2=0.02122778 \
    lkt2=-5.743292291000001E-9 ua1=-2.42902207E-9 lua1=3.816539507165E-16 ub1=2.4443796E-18 \
    lub1=-4.0006627012E-25 uc1=5.2148775E-12 luc1=-5.195283211249999E-19 at=6.394335E4 \
    lat=2.4945216175E-3 prt=0 njs=1.2928 xtis=2 \
    tpb=1.2287E-3 tpbsw=0 tpbswg=0 tcj=7.92E-4 \
    tcjsw=1E-5 tcjswg=0 tvoff=0 tvfbsdoff=0 \
    saref=1.1E-6 sbref=1.1E-6 wlod=0 ku0=-2.7E-8 \
    kvsat=0.2 kvth0=7.9E-9 tku0=0 llodku0=0 \
    wlodku0=1 llodvth=0 wlodvth=1 lku0=0 \
    wku0=0 pku0=0 lkvth0=0 wkvth0=3E-7 \
    pkvth0=0 stk2=0 lodk2=1 steta0=0 \
    lodeta0=1 rsh=488.8435114503817

// l=0.15 w=39.3 nf=22 -> bin nlowvt_model.8  rsh=493.3779 delvto=0 (folded into vth0)
model nlowvt_model__w39p3nf22 bsim4 \
    type=n version=4.50 binunit=2 mobmod=0 \
    capmod=2 rdsmod=0 igcmod=0 igbmod=0 \
    rbodymod=1 trnqsmod=0 acnqsmod=0 fnoimod=1 \
    tnoimod=1 diomod=1 tempmod=0 permod=1 \
    geomod=0 rgatemod=0 epsrox=3.9 toxe=4.148E-9 \
    toxm=4.148E-9 dtox=0 xj=1.5E-7 ndep=1.7E17 \
    ngate=9.999999999999999E22 nsd=1E20 rshg=0.1 phin=0 \
    wint=2.6e-08 wl=0 wln=1 ww=0 \
    wwn=1 wwl=0 lint=1.2025e-08 ll=0 \
    lln=1 lw=0 lwn=1 lwl=0 \
    llc=0 lwc=0 lwlc=0 wlc=0 \
    wwc=0 wwlc=0 dwg=-1.33E-8 dwb=-1.08E-8 \
    xl=0 xw=0 dmcg=0 dmdg=0 \
    dmcgt=0 xgw=0 xgl=0 ngcon=1 \
    vth0=0.249959346666667 lvth0=-1.985141612666671E-9 vfb=0 k1=1.011211866666667 \
    lk1=-4.876429660666666E-8 k2=-0.21737859252 lk2=1.7355223637994E-8 k3=1.65 \
    k3b=1.6 w0=1E-7 lpe0=2.3802E-7 lpeb=-4.9152E-8 \
    vbm=-3 dvtp0=0 dvtp1=0 dvt0=0.07665 \
    dvt1=0.1252 dvt2=-0.05637 dvt0w=0 dvt1w=5.3E6 \
    dvt2w=-0.032 vfbsdoff=0 u0=0.01421071555 lu0=2.166698264775001E-10 \
    ua=-3.496851672833332E-9 lua=1.729222681883582E-16 ub=4.57941585E-18 lub=-2.719028563075E-25 \
    uc=1.863698448333334E-10 luc=-2.261771620175834E-17 ud=0 up=0 \
    lp=1 eu=1.67 vsat=1.819855189500001E5 lvsat=-1.786254255252507E-3 \
    a0=0 ags=1.005218833333333 lags=3.096873294166675E-8 b0=0 \
    b1=0 keta=0.1569286063 lketa=-4.276737497598501E-8 a1=0 \
    a2=0.38689047 rdsw=103.65 rdswmin=0 rdw=0 \
    rdwmin=0 rsw=0 rswmin=0 prwb=0 \
    prwg=0 wr=1 voff=-0.11934831869 lvoff=5.296050099455504E-9 \
    voffl=0 minv=0 nfactor=0.723459400166666 lnfactor=3.583940752490084E-7 \
    eta0=0.067637351756667 leta0=1.529144370447834E-9 etab=-0.077077273825 letab=9.70788263825875E-9 \
    dsub=0.58180516425 ldsub=-4.053136043728748E-8 cit=5E-6 cdsc=3.8556E-37 \
    cdscb=-1.1484E-4 cdscd=4.7984E-6 pclm=0.086824416666667 lpclm=9.59179572083335E-9 \
    pdiblc1=3.583688213883334 lpdiblc1=-4.029261769551058E-7 pdiblc2=0.064735802833333 lpdiblc2=-7.957785851858334E-9 \
    pdiblcb=0 drout=3.4946 pscbe1=4.5E8 pscbe2=1E-8 \
    pvag=0 delta=0.01 fprout=0 pdits=1.4427E-15 \
    pditsl=0 pditsd=0 lambda=0 vtl=0 \
    lc=0 xn=0 alpha0=1.687407635666667E-3 lalpha0=-1.627859334572167E-10 \
    alpha1=0 beta0=31.24083182666667 lbeta0=-3.496153888186668E-7 aigbacc=1 \
    bigbacc=0 cigbacc=0 nigbacc=1 aigbinv=0.35 \
    bigbinv=0.03 cigbinv=6E-3 eigbinv=1.1 nigbinv=3 \
    aigc=0.43 bigc=0.054 cigc=0.075 aigsd=0.43 \
    bigsd=0.054 cigsd=0.075 dlcig=0 nigc=1 \
    poxedge=1 pigcd=1 ntox=1 toxref=4.148E-9 \
    agidl=0 bgidl=2.3E9 cgidl=0.5 egidl=0.8 \
    noia=9E41 noib=1E27 noic=8E11 em=4.1E7 \
    af=1 ef=1.2 kf=0 lintnoi=-3E-7 \
    tnoia=2.5E7 tnoib=9.9E6 ntnoi=1 rnoia=0.912 \
    rnoib=0.26 xpart=0 cgso=2.392894381e-10 cgdo=2.392894381e-10 \
    cgbo=1e-14 ckappas=0.6 cf=1E-14 clc=1E-7 \
    cle=0.6 dlc=1.21071E-8 dwc=2.6E-8 vfbcv=-1 \
    noff=3.8661 voffcv=-0.16994 acde=0.38008 moin=23.81 \
    cgsl=2.310725e-11 cgdl=2.310725e-11 ijthsrev=0.1 ijthsfwd=0.1 \
    xjbvs=1 bvs=11.9 jss=2.75E-3 jsws=6E-10 \
    cjs=0.00121 mjs=0.42197 mjsws=1E-3 cjsws=3.230311424e-11 \
    cjswgs=1.795291232e-10 mjswgs=0.8 pbs=0.7477 pbsws=0.1 \
    pbswgs=0.79644 xrcrg1=12 xrcrg2=1 rbpb=50 \
    rbpd=50 rbps=50 rbdb=50 rbsb=50 \
    gbmin=1E-12 tnom=30 ute=-2.841387833333333 lute=1.462012276083332E-7 \
    kt1=-0.295119316666667 lkt1=-2.874265065833337E-9 kt1l=0 kt2=0.02122778 \
    lkt2=-5.743292291000001E-9 ua1=-2.42902207E-9 lua1=3.816539507165E-16 ub1=2.4443796E-18 \
    lub1=-4.0006627012E-25 uc1=5.2148775E-12 luc1=-5.195283211249999E-19 at=6.394335E4 \
    lat=2.4945216175E-3 prt=0 njs=1.2928 xtis=2 \
    tpb=1.2287E-3 tpbsw=0 tpbswg=0 tcj=7.92E-4 \
    tcjsw=1E-5 tcjswg=0 tvoff=0 tvfbsdoff=0 \
    saref=1.1E-6 sbref=1.1E-6 wlod=0 ku0=-2.7E-8 \
    kvsat=0.2 kvth0=7.9E-9 tku0=0 llodku0=0 \
    wlodku0=1 llodvth=0 wlodvth=1 lku0=0 \
    wku0=0 pku0=0 lkvth0=0 wkvth0=3E-7 \
    pkvth0=0 stk2=0 lodk2=1 steta0=0 \
    lodeta0=1 rsh=493.37786259541986

// l=0.15 w=39.3 nf=24 -> bin nlowvt_model.8  rsh=497.9122 delvto=0 (folded into vth0)
model nlowvt_model__w39p3nf24 bsim4 \
    type=n version=4.50 binunit=2 mobmod=0 \
    capmod=2 rdsmod=0 igcmod=0 igbmod=0 \
    rbodymod=1 trnqsmod=0 acnqsmod=0 fnoimod=1 \
    tnoimod=1 diomod=1 tempmod=0 permod=1 \
    geomod=0 rgatemod=0 epsrox=3.9 toxe=4.148E-9 \
    toxm=4.148E-9 dtox=0 xj=1.5E-7 ndep=1.7E17 \
    ngate=9.999999999999999E22 nsd=1E20 rshg=0.1 phin=0 \
    wint=2.6e-08 wl=0 wln=1 ww=0 \
    wwn=1 wwl=0 lint=1.2025e-08 ll=0 \
    lln=1 lw=0 lwn=1 lwl=0 \
    llc=0 lwc=0 lwlc=0 wlc=0 \
    wwc=0 wwlc=0 dwg=-1.33E-8 dwb=-1.08E-8 \
    xl=0 xw=0 dmcg=0 dmdg=0 \
    dmcgt=0 xgw=0 xgl=0 ngcon=1 \
    vth0=0.249959346666667 lvth0=-1.985141612666671E-9 vfb=0 k1=1.011211866666667 \
    lk1=-4.876429660666666E-8 k2=-0.21737859252 lk2=1.7355223637994E-8 k3=1.65 \
    k3b=1.6 w0=1E-7 lpe0=2.3802E-7 lpeb=-4.9152E-8 \
    vbm=-3 dvtp0=0 dvtp1=0 dvt0=0.07665 \
    dvt1=0.1252 dvt2=-0.05637 dvt0w=0 dvt1w=5.3E6 \
    dvt2w=-0.032 vfbsdoff=0 u0=0.01421071555 lu0=2.166698264775001E-10 \
    ua=-3.496851672833332E-9 lua=1.729222681883582E-16 ub=4.57941585E-18 lub=-2.719028563075E-25 \
    uc=1.863698448333334E-10 luc=-2.261771620175834E-17 ud=0 up=0 \
    lp=1 eu=1.67 vsat=1.819855189500001E5 lvsat=-1.786254255252507E-3 \
    a0=0 ags=1.005218833333333 lags=3.096873294166675E-8 b0=0 \
    b1=0 keta=0.1569286063 lketa=-4.276737497598501E-8 a1=0 \
    a2=0.38689047 rdsw=103.65 rdswmin=0 rdw=0 \
    rdwmin=0 rsw=0 rswmin=0 prwb=0 \
    prwg=0 wr=1 voff=-0.11934831869 lvoff=5.296050099455504E-9 \
    voffl=0 minv=0 nfactor=0.723459400166666 lnfactor=3.583940752490084E-7 \
    eta0=0.067637351756667 leta0=1.529144370447834E-9 etab=-0.077077273825 letab=9.70788263825875E-9 \
    dsub=0.58180516425 ldsub=-4.053136043728748E-8 cit=5E-6 cdsc=3.8556E-37 \
    cdscb=-1.1484E-4 cdscd=4.7984E-6 pclm=0.086824416666667 lpclm=9.59179572083335E-9 \
    pdiblc1=3.583688213883334 lpdiblc1=-4.029261769551058E-7 pdiblc2=0.064735802833333 lpdiblc2=-7.957785851858334E-9 \
    pdiblcb=0 drout=3.4946 pscbe1=4.5E8 pscbe2=1E-8 \
    pvag=0 delta=0.01 fprout=0 pdits=1.4427E-15 \
    pditsl=0 pditsd=0 lambda=0 vtl=0 \
    lc=0 xn=0 alpha0=1.687407635666667E-3 lalpha0=-1.627859334572167E-10 \
    alpha1=0 beta0=31.24083182666667 lbeta0=-3.496153888186668E-7 aigbacc=1 \
    bigbacc=0 cigbacc=0 nigbacc=1 aigbinv=0.35 \
    bigbinv=0.03 cigbinv=6E-3 eigbinv=1.1 nigbinv=3 \
    aigc=0.43 bigc=0.054 cigc=0.075 aigsd=0.43 \
    bigsd=0.054 cigsd=0.075 dlcig=0 nigc=1 \
    poxedge=1 pigcd=1 ntox=1 toxref=4.148E-9 \
    agidl=0 bgidl=2.3E9 cgidl=0.5 egidl=0.8 \
    noia=9E41 noib=1E27 noic=8E11 em=4.1E7 \
    af=1 ef=1.2 kf=0 lintnoi=-3E-7 \
    tnoia=2.5E7 tnoib=9.9E6 ntnoi=1 rnoia=0.912 \
    rnoib=0.26 xpart=0 cgso=2.392894381e-10 cgdo=2.392894381e-10 \
    cgbo=1e-14 ckappas=0.6 cf=1E-14 clc=1E-7 \
    cle=0.6 dlc=1.21071E-8 dwc=2.6E-8 vfbcv=-1 \
    noff=3.8661 voffcv=-0.16994 acde=0.38008 moin=23.81 \
    cgsl=2.310725e-11 cgdl=2.310725e-11 ijthsrev=0.1 ijthsfwd=0.1 \
    xjbvs=1 bvs=11.9 jss=2.75E-3 jsws=6E-10 \
    cjs=0.00121 mjs=0.42197 mjsws=1E-3 cjsws=3.230311424e-11 \
    cjswgs=1.795291232e-10 mjswgs=0.8 pbs=0.7477 pbsws=0.1 \
    pbswgs=0.79644 xrcrg1=12 xrcrg2=1 rbpb=50 \
    rbpd=50 rbps=50 rbdb=50 rbsb=50 \
    gbmin=1E-12 tnom=30 ute=-2.841387833333333 lute=1.462012276083332E-7 \
    kt1=-0.295119316666667 lkt1=-2.874265065833337E-9 kt1l=0 kt2=0.02122778 \
    lkt2=-5.743292291000001E-9 ua1=-2.42902207E-9 lua1=3.816539507165E-16 ub1=2.4443796E-18 \
    lub1=-4.0006627012E-25 uc1=5.2148775E-12 luc1=-5.195283211249999E-19 at=6.394335E4 \
    lat=2.4945216175E-3 prt=0 njs=1.2928 xtis=2 \
    tpb=1.2287E-3 tpbsw=0 tpbswg=0 tcj=7.92E-4 \
    tcjsw=1E-5 tcjswg=0 tvoff=0 tvfbsdoff=0 \
    saref=1.1E-6 sbref=1.1E-6 wlod=0 ku0=-2.7E-8 \
    kvsat=0.2 kvth0=7.9E-9 tku0=0 llodku0=0 \
    wlodku0=1 llodvth=0 wlodvth=1 lku0=0 \
    wku0=0 pku0=0 lkvth0=0 wkvth0=3E-7 \
    pkvth0=0 stk2=0 lodk2=1 steta0=0 \
    lodeta0=1 rsh=497.912213740458

// l=0.15 w=39.3 nf=26 -> bin nlowvt_model.8  rsh=502.4466 delvto=0 (folded into vth0)
model nlowvt_model__w39p3nf26 bsim4 \
    type=n version=4.50 binunit=2 mobmod=0 \
    capmod=2 rdsmod=0 igcmod=0 igbmod=0 \
    rbodymod=1 trnqsmod=0 acnqsmod=0 fnoimod=1 \
    tnoimod=1 diomod=1 tempmod=0 permod=1 \
    geomod=0 rgatemod=0 epsrox=3.9 toxe=4.148E-9 \
    toxm=4.148E-9 dtox=0 xj=1.5E-7 ndep=1.7E17 \
    ngate=9.999999999999999E22 nsd=1E20 rshg=0.1 phin=0 \
    wint=2.6e-08 wl=0 wln=1 ww=0 \
    wwn=1 wwl=0 lint=1.2025e-08 ll=0 \
    lln=1 lw=0 lwn=1 lwl=0 \
    llc=0 lwc=0 lwlc=0 wlc=0 \
    wwc=0 wwlc=0 dwg=-1.33E-8 dwb=-1.08E-8 \
    xl=0 xw=0 dmcg=0 dmdg=0 \
    dmcgt=0 xgw=0 xgl=0 ngcon=1 \
    vth0=0.249959346666667 lvth0=-1.985141612666671E-9 vfb=0 k1=1.011211866666667 \
    lk1=-4.876429660666666E-8 k2=-0.21737859252 lk2=1.7355223637994E-8 k3=1.65 \
    k3b=1.6 w0=1E-7 lpe0=2.3802E-7 lpeb=-4.9152E-8 \
    vbm=-3 dvtp0=0 dvtp1=0 dvt0=0.07665 \
    dvt1=0.1252 dvt2=-0.05637 dvt0w=0 dvt1w=5.3E6 \
    dvt2w=-0.032 vfbsdoff=0 u0=0.01421071555 lu0=2.166698264775001E-10 \
    ua=-3.496851672833332E-9 lua=1.729222681883582E-16 ub=4.57941585E-18 lub=-2.719028563075E-25 \
    uc=1.863698448333334E-10 luc=-2.261771620175834E-17 ud=0 up=0 \
    lp=1 eu=1.67 vsat=1.819855189500001E5 lvsat=-1.786254255252507E-3 \
    a0=0 ags=1.005218833333333 lags=3.096873294166675E-8 b0=0 \
    b1=0 keta=0.1569286063 lketa=-4.276737497598501E-8 a1=0 \
    a2=0.38689047 rdsw=103.65 rdswmin=0 rdw=0 \
    rdwmin=0 rsw=0 rswmin=0 prwb=0 \
    prwg=0 wr=1 voff=-0.11934831869 lvoff=5.296050099455504E-9 \
    voffl=0 minv=0 nfactor=0.723459400166666 lnfactor=3.583940752490084E-7 \
    eta0=0.067637351756667 leta0=1.529144370447834E-9 etab=-0.077077273825 letab=9.70788263825875E-9 \
    dsub=0.58180516425 ldsub=-4.053136043728748E-8 cit=5E-6 cdsc=3.8556E-37 \
    cdscb=-1.1484E-4 cdscd=4.7984E-6 pclm=0.086824416666667 lpclm=9.59179572083335E-9 \
    pdiblc1=3.583688213883334 lpdiblc1=-4.029261769551058E-7 pdiblc2=0.064735802833333 lpdiblc2=-7.957785851858334E-9 \
    pdiblcb=0 drout=3.4946 pscbe1=4.5E8 pscbe2=1E-8 \
    pvag=0 delta=0.01 fprout=0 pdits=1.4427E-15 \
    pditsl=0 pditsd=0 lambda=0 vtl=0 \
    lc=0 xn=0 alpha0=1.687407635666667E-3 lalpha0=-1.627859334572167E-10 \
    alpha1=0 beta0=31.24083182666667 lbeta0=-3.496153888186668E-7 aigbacc=1 \
    bigbacc=0 cigbacc=0 nigbacc=1 aigbinv=0.35 \
    bigbinv=0.03 cigbinv=6E-3 eigbinv=1.1 nigbinv=3 \
    aigc=0.43 bigc=0.054 cigc=0.075 aigsd=0.43 \
    bigsd=0.054 cigsd=0.075 dlcig=0 nigc=1 \
    poxedge=1 pigcd=1 ntox=1 toxref=4.148E-9 \
    agidl=0 bgidl=2.3E9 cgidl=0.5 egidl=0.8 \
    noia=9E41 noib=1E27 noic=8E11 em=4.1E7 \
    af=1 ef=1.2 kf=0 lintnoi=-3E-7 \
    tnoia=2.5E7 tnoib=9.9E6 ntnoi=1 rnoia=0.912 \
    rnoib=0.26 xpart=0 cgso=2.392894381e-10 cgdo=2.392894381e-10 \
    cgbo=1e-14 ckappas=0.6 cf=1E-14 clc=1E-7 \
    cle=0.6 dlc=1.21071E-8 dwc=2.6E-8 vfbcv=-1 \
    noff=3.8661 voffcv=-0.16994 acde=0.38008 moin=23.81 \
    cgsl=2.310725e-11 cgdl=2.310725e-11 ijthsrev=0.1 ijthsfwd=0.1 \
    xjbvs=1 bvs=11.9 jss=2.75E-3 jsws=6E-10 \
    cjs=0.00121 mjs=0.42197 mjsws=1E-3 cjsws=3.230311424e-11 \
    cjswgs=1.795291232e-10 mjswgs=0.8 pbs=0.7477 pbsws=0.1 \
    pbswgs=0.79644 xrcrg1=12 xrcrg2=1 rbpb=50 \
    rbpd=50 rbps=50 rbdb=50 rbsb=50 \
    gbmin=1E-12 tnom=30 ute=-2.841387833333333 lute=1.462012276083332E-7 \
    kt1=-0.295119316666667 lkt1=-2.874265065833337E-9 kt1l=0 kt2=0.02122778 \
    lkt2=-5.743292291000001E-9 ua1=-2.42902207E-9 lua1=3.816539507165E-16 ub1=2.4443796E-18 \
    lub1=-4.0006627012E-25 uc1=5.2148775E-12 luc1=-5.195283211249999E-19 at=6.394335E4 \
    lat=2.4945216175E-3 prt=0 njs=1.2928 xtis=2 \
    tpb=1.2287E-3 tpbsw=0 tpbswg=0 tcj=7.92E-4 \
    tcjsw=1E-5 tcjswg=0 tvoff=0 tvfbsdoff=0 \
    saref=1.1E-6 sbref=1.1E-6 wlod=0 ku0=-2.7E-8 \
    kvsat=0.2 kvth0=7.9E-9 tku0=0 llodku0=0 \
    wlodku0=1 llodvth=0 wlodvth=1 lku0=0 \
    wku0=0 pku0=0 lkvth0=0 wkvth0=3E-7 \
    pkvth0=0 stk2=0 lodk2=1 steta0=0 \
    lodeta0=1 rsh=502.4465648854962

// l=0.15 w=43.3 nf=18 -> bin nlowvt_model.8  rsh=480.5393 delvto=0 (folded into vth0)
model nlowvt_model__w43p3nf18 bsim4 \
    type=n version=4.50 binunit=2 mobmod=0 \
    capmod=2 rdsmod=0 igcmod=0 igbmod=0 \
    rbodymod=1 trnqsmod=0 acnqsmod=0 fnoimod=1 \
    tnoimod=1 diomod=1 tempmod=0 permod=1 \
    geomod=0 rgatemod=0 epsrox=3.9 toxe=4.148E-9 \
    toxm=4.148E-9 dtox=0 xj=1.5E-7 ndep=1.7E17 \
    ngate=9.999999999999999E22 nsd=1E20 rshg=0.1 phin=0 \
    wint=2.6e-08 wl=0 wln=1 ww=0 \
    wwn=1 wwl=0 lint=1.2025e-08 ll=0 \
    lln=1 lw=0 lwn=1 lwl=0 \
    llc=0 lwc=0 lwlc=0 wlc=0 \
    wwc=0 wwlc=0 dwg=-1.33E-8 dwb=-1.08E-8 \
    xl=0 xw=0 dmcg=0 dmdg=0 \
    dmcgt=0 xgw=0 xgl=0 ngcon=1 \
    vth0=0.249959346666667 lvth0=-1.985141612666671E-9 vfb=0 k1=1.011211866666667 \
    lk1=-4.876429660666666E-8 k2=-0.21737859252 lk2=1.7355223637994E-8 k3=1.65 \
    k3b=1.6 w0=1E-7 lpe0=2.3802E-7 lpeb=-4.9152E-8 \
    vbm=-3 dvtp0=0 dvtp1=0 dvt0=0.07665 \
    dvt1=0.1252 dvt2=-0.05637 dvt0w=0 dvt1w=5.3E6 \
    dvt2w=-0.032 vfbsdoff=0 u0=0.01421071555 lu0=2.166698264775001E-10 \
    ua=-3.496851672833332E-9 lua=1.729222681883582E-16 ub=4.57941585E-18 lub=-2.719028563075E-25 \
    uc=1.863698448333334E-10 luc=-2.261771620175834E-17 ud=0 up=0 \
    lp=1 eu=1.67 vsat=1.819855189500001E5 lvsat=-1.786254255252507E-3 \
    a0=0 ags=1.005218833333333 lags=3.096873294166675E-8 b0=0 \
    b1=0 keta=0.1569286063 lketa=-4.276737497598501E-8 a1=0 \
    a2=0.38689047 rdsw=103.65 rdswmin=0 rdw=0 \
    rdwmin=0 rsw=0 rswmin=0 prwb=0 \
    prwg=0 wr=1 voff=-0.11934831869 lvoff=5.296050099455504E-9 \
    voffl=0 minv=0 nfactor=0.723459400166666 lnfactor=3.583940752490084E-7 \
    eta0=0.067637351756667 leta0=1.529144370447834E-9 etab=-0.077077273825 letab=9.70788263825875E-9 \
    dsub=0.58180516425 ldsub=-4.053136043728748E-8 cit=5E-6 cdsc=3.8556E-37 \
    cdscb=-1.1484E-4 cdscd=4.7984E-6 pclm=0.086824416666667 lpclm=9.59179572083335E-9 \
    pdiblc1=3.583688213883334 lpdiblc1=-4.029261769551058E-7 pdiblc2=0.064735802833333 lpdiblc2=-7.957785851858334E-9 \
    pdiblcb=0 drout=3.4946 pscbe1=4.5E8 pscbe2=1E-8 \
    pvag=0 delta=0.01 fprout=0 pdits=1.4427E-15 \
    pditsl=0 pditsd=0 lambda=0 vtl=0 \
    lc=0 xn=0 alpha0=1.687407635666667E-3 lalpha0=-1.627859334572167E-10 \
    alpha1=0 beta0=31.24083182666667 lbeta0=-3.496153888186668E-7 aigbacc=1 \
    bigbacc=0 cigbacc=0 nigbacc=1 aigbinv=0.35 \
    bigbinv=0.03 cigbinv=6E-3 eigbinv=1.1 nigbinv=3 \
    aigc=0.43 bigc=0.054 cigc=0.075 aigsd=0.43 \
    bigsd=0.054 cigsd=0.075 dlcig=0 nigc=1 \
    poxedge=1 pigcd=1 ntox=1 toxref=4.148E-9 \
    agidl=0 bgidl=2.3E9 cgidl=0.5 egidl=0.8 \
    noia=9E41 noib=1E27 noic=8E11 em=4.1E7 \
    af=1 ef=1.2 kf=0 lintnoi=-3E-7 \
    tnoia=2.5E7 tnoib=9.9E6 ntnoi=1 rnoia=0.912 \
    rnoib=0.26 xpart=0 cgso=2.392894381e-10 cgdo=2.392894381e-10 \
    cgbo=1e-14 ckappas=0.6 cf=1E-14 clc=1E-7 \
    cle=0.6 dlc=1.21071E-8 dwc=2.6E-8 vfbcv=-1 \
    noff=3.8661 voffcv=-0.16994 acde=0.38008 moin=23.81 \
    cgsl=2.310725e-11 cgdl=2.310725e-11 ijthsrev=0.1 ijthsfwd=0.1 \
    xjbvs=1 bvs=11.9 jss=2.75E-3 jsws=6E-10 \
    cjs=0.00121 mjs=0.42197 mjsws=1E-3 cjsws=3.230311424e-11 \
    cjswgs=1.795291232e-10 mjswgs=0.8 pbs=0.7477 pbsws=0.1 \
    pbswgs=0.79644 xrcrg1=12 xrcrg2=1 rbpb=50 \
    rbpd=50 rbps=50 rbdb=50 rbsb=50 \
    gbmin=1E-12 tnom=30 ute=-2.841387833333333 lute=1.462012276083332E-7 \
    kt1=-0.295119316666667 lkt1=-2.874265065833337E-9 kt1l=0 kt2=0.02122778 \
    lkt2=-5.743292291000001E-9 ua1=-2.42902207E-9 lua1=3.816539507165E-16 ub1=2.4443796E-18 \
    lub1=-4.0006627012E-25 uc1=5.2148775E-12 luc1=-5.195283211249999E-19 at=6.394335E4 \
    lat=2.4945216175E-3 prt=0 njs=1.2928 xtis=2 \
    tpb=1.2287E-3 tpbsw=0 tpbswg=0 tcj=7.92E-4 \
    tcjsw=1E-5 tcjswg=0 tvoff=0 tvfbsdoff=0 \
    saref=1.1E-6 sbref=1.1E-6 wlod=0 ku0=-2.7E-8 \
    kvsat=0.2 kvth0=7.9E-9 tku0=0 llodku0=0 \
    wlodku0=1 llodvth=0 wlodvth=1 lku0=0 \
    wku0=0 pku0=0 lkvth0=0 wkvth0=3E-7 \
    pkvth0=0 stk2=0 lodk2=1 steta0=0 \
    lodeta0=1 rsh=480.5392609699769

// l=0.15 w=43.3 nf=20 -> bin nlowvt_model.8  rsh=484.6547 delvto=0 (folded into vth0)
model nlowvt_model__w43p3nf20 bsim4 \
    type=n version=4.50 binunit=2 mobmod=0 \
    capmod=2 rdsmod=0 igcmod=0 igbmod=0 \
    rbodymod=1 trnqsmod=0 acnqsmod=0 fnoimod=1 \
    tnoimod=1 diomod=1 tempmod=0 permod=1 \
    geomod=0 rgatemod=0 epsrox=3.9 toxe=4.148E-9 \
    toxm=4.148E-9 dtox=0 xj=1.5E-7 ndep=1.7E17 \
    ngate=9.999999999999999E22 nsd=1E20 rshg=0.1 phin=0 \
    wint=2.6e-08 wl=0 wln=1 ww=0 \
    wwn=1 wwl=0 lint=1.2025e-08 ll=0 \
    lln=1 lw=0 lwn=1 lwl=0 \
    llc=0 lwc=0 lwlc=0 wlc=0 \
    wwc=0 wwlc=0 dwg=-1.33E-8 dwb=-1.08E-8 \
    xl=0 xw=0 dmcg=0 dmdg=0 \
    dmcgt=0 xgw=0 xgl=0 ngcon=1 \
    vth0=0.249959346666667 lvth0=-1.985141612666671E-9 vfb=0 k1=1.011211866666667 \
    lk1=-4.876429660666666E-8 k2=-0.21737859252 lk2=1.7355223637994E-8 k3=1.65 \
    k3b=1.6 w0=1E-7 lpe0=2.3802E-7 lpeb=-4.9152E-8 \
    vbm=-3 dvtp0=0 dvtp1=0 dvt0=0.07665 \
    dvt1=0.1252 dvt2=-0.05637 dvt0w=0 dvt1w=5.3E6 \
    dvt2w=-0.032 vfbsdoff=0 u0=0.01421071555 lu0=2.166698264775001E-10 \
    ua=-3.496851672833332E-9 lua=1.729222681883582E-16 ub=4.57941585E-18 lub=-2.719028563075E-25 \
    uc=1.863698448333334E-10 luc=-2.261771620175834E-17 ud=0 up=0 \
    lp=1 eu=1.67 vsat=1.819855189500001E5 lvsat=-1.786254255252507E-3 \
    a0=0 ags=1.005218833333333 lags=3.096873294166675E-8 b0=0 \
    b1=0 keta=0.1569286063 lketa=-4.276737497598501E-8 a1=0 \
    a2=0.38689047 rdsw=103.65 rdswmin=0 rdw=0 \
    rdwmin=0 rsw=0 rswmin=0 prwb=0 \
    prwg=0 wr=1 voff=-0.11934831869 lvoff=5.296050099455504E-9 \
    voffl=0 minv=0 nfactor=0.723459400166666 lnfactor=3.583940752490084E-7 \
    eta0=0.067637351756667 leta0=1.529144370447834E-9 etab=-0.077077273825 letab=9.70788263825875E-9 \
    dsub=0.58180516425 ldsub=-4.053136043728748E-8 cit=5E-6 cdsc=3.8556E-37 \
    cdscb=-1.1484E-4 cdscd=4.7984E-6 pclm=0.086824416666667 lpclm=9.59179572083335E-9 \
    pdiblc1=3.583688213883334 lpdiblc1=-4.029261769551058E-7 pdiblc2=0.064735802833333 lpdiblc2=-7.957785851858334E-9 \
    pdiblcb=0 drout=3.4946 pscbe1=4.5E8 pscbe2=1E-8 \
    pvag=0 delta=0.01 fprout=0 pdits=1.4427E-15 \
    pditsl=0 pditsd=0 lambda=0 vtl=0 \
    lc=0 xn=0 alpha0=1.687407635666667E-3 lalpha0=-1.627859334572167E-10 \
    alpha1=0 beta0=31.24083182666667 lbeta0=-3.496153888186668E-7 aigbacc=1 \
    bigbacc=0 cigbacc=0 nigbacc=1 aigbinv=0.35 \
    bigbinv=0.03 cigbinv=6E-3 eigbinv=1.1 nigbinv=3 \
    aigc=0.43 bigc=0.054 cigc=0.075 aigsd=0.43 \
    bigsd=0.054 cigsd=0.075 dlcig=0 nigc=1 \
    poxedge=1 pigcd=1 ntox=1 toxref=4.148E-9 \
    agidl=0 bgidl=2.3E9 cgidl=0.5 egidl=0.8 \
    noia=9E41 noib=1E27 noic=8E11 em=4.1E7 \
    af=1 ef=1.2 kf=0 lintnoi=-3E-7 \
    tnoia=2.5E7 tnoib=9.9E6 ntnoi=1 rnoia=0.912 \
    rnoib=0.26 xpart=0 cgso=2.392894381e-10 cgdo=2.392894381e-10 \
    cgbo=1e-14 ckappas=0.6 cf=1E-14 clc=1E-7 \
    cle=0.6 dlc=1.21071E-8 dwc=2.6E-8 vfbcv=-1 \
    noff=3.8661 voffcv=-0.16994 acde=0.38008 moin=23.81 \
    cgsl=2.310725e-11 cgdl=2.310725e-11 ijthsrev=0.1 ijthsfwd=0.1 \
    xjbvs=1 bvs=11.9 jss=2.75E-3 jsws=6E-10 \
    cjs=0.00121 mjs=0.42197 mjsws=1E-3 cjsws=3.230311424e-11 \
    cjswgs=1.795291232e-10 mjswgs=0.8 pbs=0.7477 pbsws=0.1 \
    pbswgs=0.79644 xrcrg1=12 xrcrg2=1 rbpb=50 \
    rbpd=50 rbps=50 rbdb=50 rbsb=50 \
    gbmin=1E-12 tnom=30 ute=-2.841387833333333 lute=1.462012276083332E-7 \
    kt1=-0.295119316666667 lkt1=-2.874265065833337E-9 kt1l=0 kt2=0.02122778 \
    lkt2=-5.743292291000001E-9 ua1=-2.42902207E-9 lua1=3.816539507165E-16 ub1=2.4443796E-18 \
    lub1=-4.0006627012E-25 uc1=5.2148775E-12 luc1=-5.195283211249999E-19 at=6.394335E4 \
    lat=2.4945216175E-3 prt=0 njs=1.2928 xtis=2 \
    tpb=1.2287E-3 tpbsw=0 tpbswg=0 tcj=7.92E-4 \
    tcjsw=1E-5 tcjswg=0 tvoff=0 tvfbsdoff=0 \
    saref=1.1E-6 sbref=1.1E-6 wlod=0 ku0=-2.7E-8 \
    kvsat=0.2 kvth0=7.9E-9 tku0=0 llodku0=0 \
    wlodku0=1 llodvth=0 wlodvth=1 lku0=0 \
    wku0=0 pku0=0 lkvth0=0 wkvth0=3E-7 \
    pkvth0=0 stk2=0 lodk2=1 steta0=0 \
    lodeta0=1 rsh=484.6547344110854

// l=0.15 w=43.3 nf=24 -> bin nlowvt_model.8  rsh=492.8857 delvto=0 (folded into vth0)
model nlowvt_model__w43p3nf24 bsim4 \
    type=n version=4.50 binunit=2 mobmod=0 \
    capmod=2 rdsmod=0 igcmod=0 igbmod=0 \
    rbodymod=1 trnqsmod=0 acnqsmod=0 fnoimod=1 \
    tnoimod=1 diomod=1 tempmod=0 permod=1 \
    geomod=0 rgatemod=0 epsrox=3.9 toxe=4.148E-9 \
    toxm=4.148E-9 dtox=0 xj=1.5E-7 ndep=1.7E17 \
    ngate=9.999999999999999E22 nsd=1E20 rshg=0.1 phin=0 \
    wint=2.6e-08 wl=0 wln=1 ww=0 \
    wwn=1 wwl=0 lint=1.2025e-08 ll=0 \
    lln=1 lw=0 lwn=1 lwl=0 \
    llc=0 lwc=0 lwlc=0 wlc=0 \
    wwc=0 wwlc=0 dwg=-1.33E-8 dwb=-1.08E-8 \
    xl=0 xw=0 dmcg=0 dmdg=0 \
    dmcgt=0 xgw=0 xgl=0 ngcon=1 \
    vth0=0.249959346666667 lvth0=-1.985141612666671E-9 vfb=0 k1=1.011211866666667 \
    lk1=-4.876429660666666E-8 k2=-0.21737859252 lk2=1.7355223637994E-8 k3=1.65 \
    k3b=1.6 w0=1E-7 lpe0=2.3802E-7 lpeb=-4.9152E-8 \
    vbm=-3 dvtp0=0 dvtp1=0 dvt0=0.07665 \
    dvt1=0.1252 dvt2=-0.05637 dvt0w=0 dvt1w=5.3E6 \
    dvt2w=-0.032 vfbsdoff=0 u0=0.01421071555 lu0=2.166698264775001E-10 \
    ua=-3.496851672833332E-9 lua=1.729222681883582E-16 ub=4.57941585E-18 lub=-2.719028563075E-25 \
    uc=1.863698448333334E-10 luc=-2.261771620175834E-17 ud=0 up=0 \
    lp=1 eu=1.67 vsat=1.819855189500001E5 lvsat=-1.786254255252507E-3 \
    a0=0 ags=1.005218833333333 lags=3.096873294166675E-8 b0=0 \
    b1=0 keta=0.1569286063 lketa=-4.276737497598501E-8 a1=0 \
    a2=0.38689047 rdsw=103.65 rdswmin=0 rdw=0 \
    rdwmin=0 rsw=0 rswmin=0 prwb=0 \
    prwg=0 wr=1 voff=-0.11934831869 lvoff=5.296050099455504E-9 \
    voffl=0 minv=0 nfactor=0.723459400166666 lnfactor=3.583940752490084E-7 \
    eta0=0.067637351756667 leta0=1.529144370447834E-9 etab=-0.077077273825 letab=9.70788263825875E-9 \
    dsub=0.58180516425 ldsub=-4.053136043728748E-8 cit=5E-6 cdsc=3.8556E-37 \
    cdscb=-1.1484E-4 cdscd=4.7984E-6 pclm=0.086824416666667 lpclm=9.59179572083335E-9 \
    pdiblc1=3.583688213883334 lpdiblc1=-4.029261769551058E-7 pdiblc2=0.064735802833333 lpdiblc2=-7.957785851858334E-9 \
    pdiblcb=0 drout=3.4946 pscbe1=4.5E8 pscbe2=1E-8 \
    pvag=0 delta=0.01 fprout=0 pdits=1.4427E-15 \
    pditsl=0 pditsd=0 lambda=0 vtl=0 \
    lc=0 xn=0 alpha0=1.687407635666667E-3 lalpha0=-1.627859334572167E-10 \
    alpha1=0 beta0=31.24083182666667 lbeta0=-3.496153888186668E-7 aigbacc=1 \
    bigbacc=0 cigbacc=0 nigbacc=1 aigbinv=0.35 \
    bigbinv=0.03 cigbinv=6E-3 eigbinv=1.1 nigbinv=3 \
    aigc=0.43 bigc=0.054 cigc=0.075 aigsd=0.43 \
    bigsd=0.054 cigsd=0.075 dlcig=0 nigc=1 \
    poxedge=1 pigcd=1 ntox=1 toxref=4.148E-9 \
    agidl=0 bgidl=2.3E9 cgidl=0.5 egidl=0.8 \
    noia=9E41 noib=1E27 noic=8E11 em=4.1E7 \
    af=1 ef=1.2 kf=0 lintnoi=-3E-7 \
    tnoia=2.5E7 tnoib=9.9E6 ntnoi=1 rnoia=0.912 \
    rnoib=0.26 xpart=0 cgso=2.392894381e-10 cgdo=2.392894381e-10 \
    cgbo=1e-14 ckappas=0.6 cf=1E-14 clc=1E-7 \
    cle=0.6 dlc=1.21071E-8 dwc=2.6E-8 vfbcv=-1 \
    noff=3.8661 voffcv=-0.16994 acde=0.38008 moin=23.81 \
    cgsl=2.310725e-11 cgdl=2.310725e-11 ijthsrev=0.1 ijthsfwd=0.1 \
    xjbvs=1 bvs=11.9 jss=2.75E-3 jsws=6E-10 \
    cjs=0.00121 mjs=0.42197 mjsws=1E-3 cjsws=3.230311424e-11 \
    cjswgs=1.795291232e-10 mjswgs=0.8 pbs=0.7477 pbsws=0.1 \
    pbswgs=0.79644 xrcrg1=12 xrcrg2=1 rbpb=50 \
    rbpd=50 rbps=50 rbdb=50 rbsb=50 \
    gbmin=1E-12 tnom=30 ute=-2.841387833333333 lute=1.462012276083332E-7 \
    kt1=-0.295119316666667 lkt1=-2.874265065833337E-9 kt1l=0 kt2=0.02122778 \
    lkt2=-5.743292291000001E-9 ua1=-2.42902207E-9 lua1=3.816539507165E-16 ub1=2.4443796E-18 \
    lub1=-4.0006627012E-25 uc1=5.2148775E-12 luc1=-5.195283211249999E-19 at=6.394335E4 \
    lat=2.4945216175E-3 prt=0 njs=1.2928 xtis=2 \
    tpb=1.2287E-3 tpbsw=0 tpbswg=0 tcj=7.92E-4 \
    tcjsw=1E-5 tcjswg=0 tvoff=0 tvfbsdoff=0 \
    saref=1.1E-6 sbref=1.1E-6 wlod=0 ku0=-2.7E-8 \
    kvsat=0.2 kvth0=7.9E-9 tku0=0 llodku0=0 \
    wlodku0=1 llodvth=0 wlodvth=1 lku0=0 \
    wku0=0 pku0=0 lkvth0=0 wkvth0=3E-7 \
    pkvth0=0 stk2=0 lodk2=1 steta0=0 \
    lodeta0=1 rsh=492.8856812933025

// l=0.15 w=43.3 nf=26 -> bin nlowvt_model.8  rsh=497.0012 delvto=0 (folded into vth0)
model nlowvt_model__w43p3nf26 bsim4 \
    type=n version=4.50 binunit=2 mobmod=0 \
    capmod=2 rdsmod=0 igcmod=0 igbmod=0 \
    rbodymod=1 trnqsmod=0 acnqsmod=0 fnoimod=1 \
    tnoimod=1 diomod=1 tempmod=0 permod=1 \
    geomod=0 rgatemod=0 epsrox=3.9 toxe=4.148E-9 \
    toxm=4.148E-9 dtox=0 xj=1.5E-7 ndep=1.7E17 \
    ngate=9.999999999999999E22 nsd=1E20 rshg=0.1 phin=0 \
    wint=2.6e-08 wl=0 wln=1 ww=0 \
    wwn=1 wwl=0 lint=1.2025e-08 ll=0 \
    lln=1 lw=0 lwn=1 lwl=0 \
    llc=0 lwc=0 lwlc=0 wlc=0 \
    wwc=0 wwlc=0 dwg=-1.33E-8 dwb=-1.08E-8 \
    xl=0 xw=0 dmcg=0 dmdg=0 \
    dmcgt=0 xgw=0 xgl=0 ngcon=1 \
    vth0=0.249959346666667 lvth0=-1.985141612666671E-9 vfb=0 k1=1.011211866666667 \
    lk1=-4.876429660666666E-8 k2=-0.21737859252 lk2=1.7355223637994E-8 k3=1.65 \
    k3b=1.6 w0=1E-7 lpe0=2.3802E-7 lpeb=-4.9152E-8 \
    vbm=-3 dvtp0=0 dvtp1=0 dvt0=0.07665 \
    dvt1=0.1252 dvt2=-0.05637 dvt0w=0 dvt1w=5.3E6 \
    dvt2w=-0.032 vfbsdoff=0 u0=0.01421071555 lu0=2.166698264775001E-10 \
    ua=-3.496851672833332E-9 lua=1.729222681883582E-16 ub=4.57941585E-18 lub=-2.719028563075E-25 \
    uc=1.863698448333334E-10 luc=-2.261771620175834E-17 ud=0 up=0 \
    lp=1 eu=1.67 vsat=1.819855189500001E5 lvsat=-1.786254255252507E-3 \
    a0=0 ags=1.005218833333333 lags=3.096873294166675E-8 b0=0 \
    b1=0 keta=0.1569286063 lketa=-4.276737497598501E-8 a1=0 \
    a2=0.38689047 rdsw=103.65 rdswmin=0 rdw=0 \
    rdwmin=0 rsw=0 rswmin=0 prwb=0 \
    prwg=0 wr=1 voff=-0.11934831869 lvoff=5.296050099455504E-9 \
    voffl=0 minv=0 nfactor=0.723459400166666 lnfactor=3.583940752490084E-7 \
    eta0=0.067637351756667 leta0=1.529144370447834E-9 etab=-0.077077273825 letab=9.70788263825875E-9 \
    dsub=0.58180516425 ldsub=-4.053136043728748E-8 cit=5E-6 cdsc=3.8556E-37 \
    cdscb=-1.1484E-4 cdscd=4.7984E-6 pclm=0.086824416666667 lpclm=9.59179572083335E-9 \
    pdiblc1=3.583688213883334 lpdiblc1=-4.029261769551058E-7 pdiblc2=0.064735802833333 lpdiblc2=-7.957785851858334E-9 \
    pdiblcb=0 drout=3.4946 pscbe1=4.5E8 pscbe2=1E-8 \
    pvag=0 delta=0.01 fprout=0 pdits=1.4427E-15 \
    pditsl=0 pditsd=0 lambda=0 vtl=0 \
    lc=0 xn=0 alpha0=1.687407635666667E-3 lalpha0=-1.627859334572167E-10 \
    alpha1=0 beta0=31.24083182666667 lbeta0=-3.496153888186668E-7 aigbacc=1 \
    bigbacc=0 cigbacc=0 nigbacc=1 aigbinv=0.35 \
    bigbinv=0.03 cigbinv=6E-3 eigbinv=1.1 nigbinv=3 \
    aigc=0.43 bigc=0.054 cigc=0.075 aigsd=0.43 \
    bigsd=0.054 cigsd=0.075 dlcig=0 nigc=1 \
    poxedge=1 pigcd=1 ntox=1 toxref=4.148E-9 \
    agidl=0 bgidl=2.3E9 cgidl=0.5 egidl=0.8 \
    noia=9E41 noib=1E27 noic=8E11 em=4.1E7 \
    af=1 ef=1.2 kf=0 lintnoi=-3E-7 \
    tnoia=2.5E7 tnoib=9.9E6 ntnoi=1 rnoia=0.912 \
    rnoib=0.26 xpart=0 cgso=2.392894381e-10 cgdo=2.392894381e-10 \
    cgbo=1e-14 ckappas=0.6 cf=1E-14 clc=1E-7 \
    cle=0.6 dlc=1.21071E-8 dwc=2.6E-8 vfbcv=-1 \
    noff=3.8661 voffcv=-0.16994 acde=0.38008 moin=23.81 \
    cgsl=2.310725e-11 cgdl=2.310725e-11 ijthsrev=0.1 ijthsfwd=0.1 \
    xjbvs=1 bvs=11.9 jss=2.75E-3 jsws=6E-10 \
    cjs=0.00121 mjs=0.42197 mjsws=1E-3 cjsws=3.230311424e-11 \
    cjswgs=1.795291232e-10 mjswgs=0.8 pbs=0.7477 pbsws=0.1 \
    pbswgs=0.79644 xrcrg1=12 xrcrg2=1 rbpb=50 \
    rbpd=50 rbps=50 rbdb=50 rbsb=50 \
    gbmin=1E-12 tnom=30 ute=-2.841387833333333 lute=1.462012276083332E-7 \
    kt1=-0.295119316666667 lkt1=-2.874265065833337E-9 kt1l=0 kt2=0.02122778 \
    lkt2=-5.743292291000001E-9 ua1=-2.42902207E-9 lua1=3.816539507165E-16 ub1=2.4443796E-18 \
    lub1=-4.0006627012E-25 uc1=5.2148775E-12 luc1=-5.195283211249999E-19 at=6.394335E4 \
    lat=2.4945216175E-3 prt=0 njs=1.2928 xtis=2 \
    tpb=1.2287E-3 tpbsw=0 tpbswg=0 tcj=7.92E-4 \
    tcjsw=1E-5 tcjswg=0 tvoff=0 tvfbsdoff=0 \
    saref=1.1E-6 sbref=1.1E-6 wlod=0 ku0=-2.7E-8 \
    kvsat=0.2 kvth0=7.9E-9 tku0=0 llodku0=0 \
    wlodku0=1 llodvth=0 wlodvth=1 lku0=0 \
    wku0=0 pku0=0 lkvth0=0 wkvth0=3E-7 \
    pkvth0=0 stk2=0 lodk2=1 steta0=0 \
    lodeta0=1 rsh=497.0011547344111

// l=0.15 w=47.3 nf=18 -> bin nlowvt_model.8  rsh=477.4070 delvto=0 (folded into vth0)
model nlowvt_model__w47p3nf18 bsim4 \
    type=n version=4.50 binunit=2 mobmod=0 \
    capmod=2 rdsmod=0 igcmod=0 igbmod=0 \
    rbodymod=1 trnqsmod=0 acnqsmod=0 fnoimod=1 \
    tnoimod=1 diomod=1 tempmod=0 permod=1 \
    geomod=0 rgatemod=0 epsrox=3.9 toxe=4.148E-9 \
    toxm=4.148E-9 dtox=0 xj=1.5E-7 ndep=1.7E17 \
    ngate=9.999999999999999E22 nsd=1E20 rshg=0.1 phin=0 \
    wint=2.6e-08 wl=0 wln=1 ww=0 \
    wwn=1 wwl=0 lint=1.2025e-08 ll=0 \
    lln=1 lw=0 lwn=1 lwl=0 \
    llc=0 lwc=0 lwlc=0 wlc=0 \
    wwc=0 wwlc=0 dwg=-1.33E-8 dwb=-1.08E-8 \
    xl=0 xw=0 dmcg=0 dmdg=0 \
    dmcgt=0 xgw=0 xgl=0 ngcon=1 \
    vth0=0.249959346666667 lvth0=-1.985141612666671E-9 vfb=0 k1=1.011211866666667 \
    lk1=-4.876429660666666E-8 k2=-0.21737859252 lk2=1.7355223637994E-8 k3=1.65 \
    k3b=1.6 w0=1E-7 lpe0=2.3802E-7 lpeb=-4.9152E-8 \
    vbm=-3 dvtp0=0 dvtp1=0 dvt0=0.07665 \
    dvt1=0.1252 dvt2=-0.05637 dvt0w=0 dvt1w=5.3E6 \
    dvt2w=-0.032 vfbsdoff=0 u0=0.01421071555 lu0=2.166698264775001E-10 \
    ua=-3.496851672833332E-9 lua=1.729222681883582E-16 ub=4.57941585E-18 lub=-2.719028563075E-25 \
    uc=1.863698448333334E-10 luc=-2.261771620175834E-17 ud=0 up=0 \
    lp=1 eu=1.67 vsat=1.819855189500001E5 lvsat=-1.786254255252507E-3 \
    a0=0 ags=1.005218833333333 lags=3.096873294166675E-8 b0=0 \
    b1=0 keta=0.1569286063 lketa=-4.276737497598501E-8 a1=0 \
    a2=0.38689047 rdsw=103.65 rdswmin=0 rdw=0 \
    rdwmin=0 rsw=0 rswmin=0 prwb=0 \
    prwg=0 wr=1 voff=-0.11934831869 lvoff=5.296050099455504E-9 \
    voffl=0 minv=0 nfactor=0.723459400166666 lnfactor=3.583940752490084E-7 \
    eta0=0.067637351756667 leta0=1.529144370447834E-9 etab=-0.077077273825 letab=9.70788263825875E-9 \
    dsub=0.58180516425 ldsub=-4.053136043728748E-8 cit=5E-6 cdsc=3.8556E-37 \
    cdscb=-1.1484E-4 cdscd=4.7984E-6 pclm=0.086824416666667 lpclm=9.59179572083335E-9 \
    pdiblc1=3.583688213883334 lpdiblc1=-4.029261769551058E-7 pdiblc2=0.064735802833333 lpdiblc2=-7.957785851858334E-9 \
    pdiblcb=0 drout=3.4946 pscbe1=4.5E8 pscbe2=1E-8 \
    pvag=0 delta=0.01 fprout=0 pdits=1.4427E-15 \
    pditsl=0 pditsd=0 lambda=0 vtl=0 \
    lc=0 xn=0 alpha0=1.687407635666667E-3 lalpha0=-1.627859334572167E-10 \
    alpha1=0 beta0=31.24083182666667 lbeta0=-3.496153888186668E-7 aigbacc=1 \
    bigbacc=0 cigbacc=0 nigbacc=1 aigbinv=0.35 \
    bigbinv=0.03 cigbinv=6E-3 eigbinv=1.1 nigbinv=3 \
    aigc=0.43 bigc=0.054 cigc=0.075 aigsd=0.43 \
    bigsd=0.054 cigsd=0.075 dlcig=0 nigc=1 \
    poxedge=1 pigcd=1 ntox=1 toxref=4.148E-9 \
    agidl=0 bgidl=2.3E9 cgidl=0.5 egidl=0.8 \
    noia=9E41 noib=1E27 noic=8E11 em=4.1E7 \
    af=1 ef=1.2 kf=0 lintnoi=-3E-7 \
    tnoia=2.5E7 tnoib=9.9E6 ntnoi=1 rnoia=0.912 \
    rnoib=0.26 xpart=0 cgso=2.392894381e-10 cgdo=2.392894381e-10 \
    cgbo=1e-14 ckappas=0.6 cf=1E-14 clc=1E-7 \
    cle=0.6 dlc=1.21071E-8 dwc=2.6E-8 vfbcv=-1 \
    noff=3.8661 voffcv=-0.16994 acde=0.38008 moin=23.81 \
    cgsl=2.310725e-11 cgdl=2.310725e-11 ijthsrev=0.1 ijthsfwd=0.1 \
    xjbvs=1 bvs=11.9 jss=2.75E-3 jsws=6E-10 \
    cjs=0.00121 mjs=0.42197 mjsws=1E-3 cjsws=3.230311424e-11 \
    cjswgs=1.795291232e-10 mjswgs=0.8 pbs=0.7477 pbsws=0.1 \
    pbswgs=0.79644 xrcrg1=12 xrcrg2=1 rbpb=50 \
    rbpd=50 rbps=50 rbdb=50 rbsb=50 \
    gbmin=1E-12 tnom=30 ute=-2.841387833333333 lute=1.462012276083332E-7 \
    kt1=-0.295119316666667 lkt1=-2.874265065833337E-9 kt1l=0 kt2=0.02122778 \
    lkt2=-5.743292291000001E-9 ua1=-2.42902207E-9 lua1=3.816539507165E-16 ub1=2.4443796E-18 \
    lub1=-4.0006627012E-25 uc1=5.2148775E-12 luc1=-5.195283211249999E-19 at=6.394335E4 \
    lat=2.4945216175E-3 prt=0 njs=1.2928 xtis=2 \
    tpb=1.2287E-3 tpbsw=0 tpbswg=0 tcj=7.92E-4 \
    tcjsw=1E-5 tcjswg=0 tvoff=0 tvfbsdoff=0 \
    saref=1.1E-6 sbref=1.1E-6 wlod=0 ku0=-2.7E-8 \
    kvsat=0.2 kvth0=7.9E-9 tku0=0 llodku0=0 \
    wlodku0=1 llodvth=0 wlodvth=1 lku0=0 \
    wku0=0 pku0=0 lkvth0=0 wkvth0=3E-7 \
    pkvth0=0 stk2=0 lodk2=1 steta0=0 \
    lodeta0=1 rsh=477.40697674418607

// l=0.15 w=47.3 nf=20 -> bin nlowvt_model.8  rsh=481.1744 delvto=0 (folded into vth0)
model nlowvt_model__w47p3nf20 bsim4 \
    type=n version=4.50 binunit=2 mobmod=0 \
    capmod=2 rdsmod=0 igcmod=0 igbmod=0 \
    rbodymod=1 trnqsmod=0 acnqsmod=0 fnoimod=1 \
    tnoimod=1 diomod=1 tempmod=0 permod=1 \
    geomod=0 rgatemod=0 epsrox=3.9 toxe=4.148E-9 \
    toxm=4.148E-9 dtox=0 xj=1.5E-7 ndep=1.7E17 \
    ngate=9.999999999999999E22 nsd=1E20 rshg=0.1 phin=0 \
    wint=2.6e-08 wl=0 wln=1 ww=0 \
    wwn=1 wwl=0 lint=1.2025e-08 ll=0 \
    lln=1 lw=0 lwn=1 lwl=0 \
    llc=0 lwc=0 lwlc=0 wlc=0 \
    wwc=0 wwlc=0 dwg=-1.33E-8 dwb=-1.08E-8 \
    xl=0 xw=0 dmcg=0 dmdg=0 \
    dmcgt=0 xgw=0 xgl=0 ngcon=1 \
    vth0=0.249959346666667 lvth0=-1.985141612666671E-9 vfb=0 k1=1.011211866666667 \
    lk1=-4.876429660666666E-8 k2=-0.21737859252 lk2=1.7355223637994E-8 k3=1.65 \
    k3b=1.6 w0=1E-7 lpe0=2.3802E-7 lpeb=-4.9152E-8 \
    vbm=-3 dvtp0=0 dvtp1=0 dvt0=0.07665 \
    dvt1=0.1252 dvt2=-0.05637 dvt0w=0 dvt1w=5.3E6 \
    dvt2w=-0.032 vfbsdoff=0 u0=0.01421071555 lu0=2.166698264775001E-10 \
    ua=-3.496851672833332E-9 lua=1.729222681883582E-16 ub=4.57941585E-18 lub=-2.719028563075E-25 \
    uc=1.863698448333334E-10 luc=-2.261771620175834E-17 ud=0 up=0 \
    lp=1 eu=1.67 vsat=1.819855189500001E5 lvsat=-1.786254255252507E-3 \
    a0=0 ags=1.005218833333333 lags=3.096873294166675E-8 b0=0 \
    b1=0 keta=0.1569286063 lketa=-4.276737497598501E-8 a1=0 \
    a2=0.38689047 rdsw=103.65 rdswmin=0 rdw=0 \
    rdwmin=0 rsw=0 rswmin=0 prwb=0 \
    prwg=0 wr=1 voff=-0.11934831869 lvoff=5.296050099455504E-9 \
    voffl=0 minv=0 nfactor=0.723459400166666 lnfactor=3.583940752490084E-7 \
    eta0=0.067637351756667 leta0=1.529144370447834E-9 etab=-0.077077273825 letab=9.70788263825875E-9 \
    dsub=0.58180516425 ldsub=-4.053136043728748E-8 cit=5E-6 cdsc=3.8556E-37 \
    cdscb=-1.1484E-4 cdscd=4.7984E-6 pclm=0.086824416666667 lpclm=9.59179572083335E-9 \
    pdiblc1=3.583688213883334 lpdiblc1=-4.029261769551058E-7 pdiblc2=0.064735802833333 lpdiblc2=-7.957785851858334E-9 \
    pdiblcb=0 drout=3.4946 pscbe1=4.5E8 pscbe2=1E-8 \
    pvag=0 delta=0.01 fprout=0 pdits=1.4427E-15 \
    pditsl=0 pditsd=0 lambda=0 vtl=0 \
    lc=0 xn=0 alpha0=1.687407635666667E-3 lalpha0=-1.627859334572167E-10 \
    alpha1=0 beta0=31.24083182666667 lbeta0=-3.496153888186668E-7 aigbacc=1 \
    bigbacc=0 cigbacc=0 nigbacc=1 aigbinv=0.35 \
    bigbinv=0.03 cigbinv=6E-3 eigbinv=1.1 nigbinv=3 \
    aigc=0.43 bigc=0.054 cigc=0.075 aigsd=0.43 \
    bigsd=0.054 cigsd=0.075 dlcig=0 nigc=1 \
    poxedge=1 pigcd=1 ntox=1 toxref=4.148E-9 \
    agidl=0 bgidl=2.3E9 cgidl=0.5 egidl=0.8 \
    noia=9E41 noib=1E27 noic=8E11 em=4.1E7 \
    af=1 ef=1.2 kf=0 lintnoi=-3E-7 \
    tnoia=2.5E7 tnoib=9.9E6 ntnoi=1 rnoia=0.912 \
    rnoib=0.26 xpart=0 cgso=2.392894381e-10 cgdo=2.392894381e-10 \
    cgbo=1e-14 ckappas=0.6 cf=1E-14 clc=1E-7 \
    cle=0.6 dlc=1.21071E-8 dwc=2.6E-8 vfbcv=-1 \
    noff=3.8661 voffcv=-0.16994 acde=0.38008 moin=23.81 \
    cgsl=2.310725e-11 cgdl=2.310725e-11 ijthsrev=0.1 ijthsfwd=0.1 \
    xjbvs=1 bvs=11.9 jss=2.75E-3 jsws=6E-10 \
    cjs=0.00121 mjs=0.42197 mjsws=1E-3 cjsws=3.230311424e-11 \
    cjswgs=1.795291232e-10 mjswgs=0.8 pbs=0.7477 pbsws=0.1 \
    pbswgs=0.79644 xrcrg1=12 xrcrg2=1 rbpb=50 \
    rbpd=50 rbps=50 rbdb=50 rbsb=50 \
    gbmin=1E-12 tnom=30 ute=-2.841387833333333 lute=1.462012276083332E-7 \
    kt1=-0.295119316666667 lkt1=-2.874265065833337E-9 kt1l=0 kt2=0.02122778 \
    lkt2=-5.743292291000001E-9 ua1=-2.42902207E-9 lua1=3.816539507165E-16 ub1=2.4443796E-18 \
    lub1=-4.0006627012E-25 uc1=5.2148775E-12 luc1=-5.195283211249999E-19 at=6.394335E4 \
    lat=2.4945216175E-3 prt=0 njs=1.2928 xtis=2 \
    tpb=1.2287E-3 tpbsw=0 tpbswg=0 tcj=7.92E-4 \
    tcjsw=1E-5 tcjswg=0 tvoff=0 tvfbsdoff=0 \
    saref=1.1E-6 sbref=1.1E-6 wlod=0 ku0=-2.7E-8 \
    kvsat=0.2 kvth0=7.9E-9 tku0=0 llodku0=0 \
    wlodku0=1 llodvth=0 wlodvth=1 lku0=0 \
    wku0=0 pku0=0 lkvth0=0 wkvth0=3E-7 \
    pkvth0=0 stk2=0 lodk2=1 steta0=0 \
    lodeta0=1 rsh=481.1744186046512

// l=0.15 w=47.3 nf=22 -> bin nlowvt_model.8  rsh=484.9419 delvto=0 (folded into vth0)
model nlowvt_model__w47p3nf22 bsim4 \
    type=n version=4.50 binunit=2 mobmod=0 \
    capmod=2 rdsmod=0 igcmod=0 igbmod=0 \
    rbodymod=1 trnqsmod=0 acnqsmod=0 fnoimod=1 \
    tnoimod=1 diomod=1 tempmod=0 permod=1 \
    geomod=0 rgatemod=0 epsrox=3.9 toxe=4.148E-9 \
    toxm=4.148E-9 dtox=0 xj=1.5E-7 ndep=1.7E17 \
    ngate=9.999999999999999E22 nsd=1E20 rshg=0.1 phin=0 \
    wint=2.6e-08 wl=0 wln=1 ww=0 \
    wwn=1 wwl=0 lint=1.2025e-08 ll=0 \
    lln=1 lw=0 lwn=1 lwl=0 \
    llc=0 lwc=0 lwlc=0 wlc=0 \
    wwc=0 wwlc=0 dwg=-1.33E-8 dwb=-1.08E-8 \
    xl=0 xw=0 dmcg=0 dmdg=0 \
    dmcgt=0 xgw=0 xgl=0 ngcon=1 \
    vth0=0.249959346666667 lvth0=-1.985141612666671E-9 vfb=0 k1=1.011211866666667 \
    lk1=-4.876429660666666E-8 k2=-0.21737859252 lk2=1.7355223637994E-8 k3=1.65 \
    k3b=1.6 w0=1E-7 lpe0=2.3802E-7 lpeb=-4.9152E-8 \
    vbm=-3 dvtp0=0 dvtp1=0 dvt0=0.07665 \
    dvt1=0.1252 dvt2=-0.05637 dvt0w=0 dvt1w=5.3E6 \
    dvt2w=-0.032 vfbsdoff=0 u0=0.01421071555 lu0=2.166698264775001E-10 \
    ua=-3.496851672833332E-9 lua=1.729222681883582E-16 ub=4.57941585E-18 lub=-2.719028563075E-25 \
    uc=1.863698448333334E-10 luc=-2.261771620175834E-17 ud=0 up=0 \
    lp=1 eu=1.67 vsat=1.819855189500001E5 lvsat=-1.786254255252507E-3 \
    a0=0 ags=1.005218833333333 lags=3.096873294166675E-8 b0=0 \
    b1=0 keta=0.1569286063 lketa=-4.276737497598501E-8 a1=0 \
    a2=0.38689047 rdsw=103.65 rdswmin=0 rdw=0 \
    rdwmin=0 rsw=0 rswmin=0 prwb=0 \
    prwg=0 wr=1 voff=-0.11934831869 lvoff=5.296050099455504E-9 \
    voffl=0 minv=0 nfactor=0.723459400166666 lnfactor=3.583940752490084E-7 \
    eta0=0.067637351756667 leta0=1.529144370447834E-9 etab=-0.077077273825 letab=9.70788263825875E-9 \
    dsub=0.58180516425 ldsub=-4.053136043728748E-8 cit=5E-6 cdsc=3.8556E-37 \
    cdscb=-1.1484E-4 cdscd=4.7984E-6 pclm=0.086824416666667 lpclm=9.59179572083335E-9 \
    pdiblc1=3.583688213883334 lpdiblc1=-4.029261769551058E-7 pdiblc2=0.064735802833333 lpdiblc2=-7.957785851858334E-9 \
    pdiblcb=0 drout=3.4946 pscbe1=4.5E8 pscbe2=1E-8 \
    pvag=0 delta=0.01 fprout=0 pdits=1.4427E-15 \
    pditsl=0 pditsd=0 lambda=0 vtl=0 \
    lc=0 xn=0 alpha0=1.687407635666667E-3 lalpha0=-1.627859334572167E-10 \
    alpha1=0 beta0=31.24083182666667 lbeta0=-3.496153888186668E-7 aigbacc=1 \
    bigbacc=0 cigbacc=0 nigbacc=1 aigbinv=0.35 \
    bigbinv=0.03 cigbinv=6E-3 eigbinv=1.1 nigbinv=3 \
    aigc=0.43 bigc=0.054 cigc=0.075 aigsd=0.43 \
    bigsd=0.054 cigsd=0.075 dlcig=0 nigc=1 \
    poxedge=1 pigcd=1 ntox=1 toxref=4.148E-9 \
    agidl=0 bgidl=2.3E9 cgidl=0.5 egidl=0.8 \
    noia=9E41 noib=1E27 noic=8E11 em=4.1E7 \
    af=1 ef=1.2 kf=0 lintnoi=-3E-7 \
    tnoia=2.5E7 tnoib=9.9E6 ntnoi=1 rnoia=0.912 \
    rnoib=0.26 xpart=0 cgso=2.392894381e-10 cgdo=2.392894381e-10 \
    cgbo=1e-14 ckappas=0.6 cf=1E-14 clc=1E-7 \
    cle=0.6 dlc=1.21071E-8 dwc=2.6E-8 vfbcv=-1 \
    noff=3.8661 voffcv=-0.16994 acde=0.38008 moin=23.81 \
    cgsl=2.310725e-11 cgdl=2.310725e-11 ijthsrev=0.1 ijthsfwd=0.1 \
    xjbvs=1 bvs=11.9 jss=2.75E-3 jsws=6E-10 \
    cjs=0.00121 mjs=0.42197 mjsws=1E-3 cjsws=3.230311424e-11 \
    cjswgs=1.795291232e-10 mjswgs=0.8 pbs=0.7477 pbsws=0.1 \
    pbswgs=0.79644 xrcrg1=12 xrcrg2=1 rbpb=50 \
    rbpd=50 rbps=50 rbdb=50 rbsb=50 \
    gbmin=1E-12 tnom=30 ute=-2.841387833333333 lute=1.462012276083332E-7 \
    kt1=-0.295119316666667 lkt1=-2.874265065833337E-9 kt1l=0 kt2=0.02122778 \
    lkt2=-5.743292291000001E-9 ua1=-2.42902207E-9 lua1=3.816539507165E-16 ub1=2.4443796E-18 \
    lub1=-4.0006627012E-25 uc1=5.2148775E-12 luc1=-5.195283211249999E-19 at=6.394335E4 \
    lat=2.4945216175E-3 prt=0 njs=1.2928 xtis=2 \
    tpb=1.2287E-3 tpbsw=0 tpbswg=0 tcj=7.92E-4 \
    tcjsw=1E-5 tcjswg=0 tvoff=0 tvfbsdoff=0 \
    saref=1.1E-6 sbref=1.1E-6 wlod=0 ku0=-2.7E-8 \
    kvsat=0.2 kvth0=7.9E-9 tku0=0 llodku0=0 \
    wlodku0=1 llodvth=0 wlodvth=1 lku0=0 \
    wku0=0 pku0=0 lkvth0=0 wkvth0=3E-7 \
    pkvth0=0 stk2=0 lodk2=1 steta0=0 \
    lodeta0=1 rsh=484.9418604651163

// l=0.15 w=47.3 nf=24 -> bin nlowvt_model.8  rsh=488.7093 delvto=0 (folded into vth0)
model nlowvt_model__w47p3nf24 bsim4 \
    type=n version=4.50 binunit=2 mobmod=0 \
    capmod=2 rdsmod=0 igcmod=0 igbmod=0 \
    rbodymod=1 trnqsmod=0 acnqsmod=0 fnoimod=1 \
    tnoimod=1 diomod=1 tempmod=0 permod=1 \
    geomod=0 rgatemod=0 epsrox=3.9 toxe=4.148E-9 \
    toxm=4.148E-9 dtox=0 xj=1.5E-7 ndep=1.7E17 \
    ngate=9.999999999999999E22 nsd=1E20 rshg=0.1 phin=0 \
    wint=2.6e-08 wl=0 wln=1 ww=0 \
    wwn=1 wwl=0 lint=1.2025e-08 ll=0 \
    lln=1 lw=0 lwn=1 lwl=0 \
    llc=0 lwc=0 lwlc=0 wlc=0 \
    wwc=0 wwlc=0 dwg=-1.33E-8 dwb=-1.08E-8 \
    xl=0 xw=0 dmcg=0 dmdg=0 \
    dmcgt=0 xgw=0 xgl=0 ngcon=1 \
    vth0=0.249959346666667 lvth0=-1.985141612666671E-9 vfb=0 k1=1.011211866666667 \
    lk1=-4.876429660666666E-8 k2=-0.21737859252 lk2=1.7355223637994E-8 k3=1.65 \
    k3b=1.6 w0=1E-7 lpe0=2.3802E-7 lpeb=-4.9152E-8 \
    vbm=-3 dvtp0=0 dvtp1=0 dvt0=0.07665 \
    dvt1=0.1252 dvt2=-0.05637 dvt0w=0 dvt1w=5.3E6 \
    dvt2w=-0.032 vfbsdoff=0 u0=0.01421071555 lu0=2.166698264775001E-10 \
    ua=-3.496851672833332E-9 lua=1.729222681883582E-16 ub=4.57941585E-18 lub=-2.719028563075E-25 \
    uc=1.863698448333334E-10 luc=-2.261771620175834E-17 ud=0 up=0 \
    lp=1 eu=1.67 vsat=1.819855189500001E5 lvsat=-1.786254255252507E-3 \
    a0=0 ags=1.005218833333333 lags=3.096873294166675E-8 b0=0 \
    b1=0 keta=0.1569286063 lketa=-4.276737497598501E-8 a1=0 \
    a2=0.38689047 rdsw=103.65 rdswmin=0 rdw=0 \
    rdwmin=0 rsw=0 rswmin=0 prwb=0 \
    prwg=0 wr=1 voff=-0.11934831869 lvoff=5.296050099455504E-9 \
    voffl=0 minv=0 nfactor=0.723459400166666 lnfactor=3.583940752490084E-7 \
    eta0=0.067637351756667 leta0=1.529144370447834E-9 etab=-0.077077273825 letab=9.70788263825875E-9 \
    dsub=0.58180516425 ldsub=-4.053136043728748E-8 cit=5E-6 cdsc=3.8556E-37 \
    cdscb=-1.1484E-4 cdscd=4.7984E-6 pclm=0.086824416666667 lpclm=9.59179572083335E-9 \
    pdiblc1=3.583688213883334 lpdiblc1=-4.029261769551058E-7 pdiblc2=0.064735802833333 lpdiblc2=-7.957785851858334E-9 \
    pdiblcb=0 drout=3.4946 pscbe1=4.5E8 pscbe2=1E-8 \
    pvag=0 delta=0.01 fprout=0 pdits=1.4427E-15 \
    pditsl=0 pditsd=0 lambda=0 vtl=0 \
    lc=0 xn=0 alpha0=1.687407635666667E-3 lalpha0=-1.627859334572167E-10 \
    alpha1=0 beta0=31.24083182666667 lbeta0=-3.496153888186668E-7 aigbacc=1 \
    bigbacc=0 cigbacc=0 nigbacc=1 aigbinv=0.35 \
    bigbinv=0.03 cigbinv=6E-3 eigbinv=1.1 nigbinv=3 \
    aigc=0.43 bigc=0.054 cigc=0.075 aigsd=0.43 \
    bigsd=0.054 cigsd=0.075 dlcig=0 nigc=1 \
    poxedge=1 pigcd=1 ntox=1 toxref=4.148E-9 \
    agidl=0 bgidl=2.3E9 cgidl=0.5 egidl=0.8 \
    noia=9E41 noib=1E27 noic=8E11 em=4.1E7 \
    af=1 ef=1.2 kf=0 lintnoi=-3E-7 \
    tnoia=2.5E7 tnoib=9.9E6 ntnoi=1 rnoia=0.912 \
    rnoib=0.26 xpart=0 cgso=2.392894381e-10 cgdo=2.392894381e-10 \
    cgbo=1e-14 ckappas=0.6 cf=1E-14 clc=1E-7 \
    cle=0.6 dlc=1.21071E-8 dwc=2.6E-8 vfbcv=-1 \
    noff=3.8661 voffcv=-0.16994 acde=0.38008 moin=23.81 \
    cgsl=2.310725e-11 cgdl=2.310725e-11 ijthsrev=0.1 ijthsfwd=0.1 \
    xjbvs=1 bvs=11.9 jss=2.75E-3 jsws=6E-10 \
    cjs=0.00121 mjs=0.42197 mjsws=1E-3 cjsws=3.230311424e-11 \
    cjswgs=1.795291232e-10 mjswgs=0.8 pbs=0.7477 pbsws=0.1 \
    pbswgs=0.79644 xrcrg1=12 xrcrg2=1 rbpb=50 \
    rbpd=50 rbps=50 rbdb=50 rbsb=50 \
    gbmin=1E-12 tnom=30 ute=-2.841387833333333 lute=1.462012276083332E-7 \
    kt1=-0.295119316666667 lkt1=-2.874265065833337E-9 kt1l=0 kt2=0.02122778 \
    lkt2=-5.743292291000001E-9 ua1=-2.42902207E-9 lua1=3.816539507165E-16 ub1=2.4443796E-18 \
    lub1=-4.0006627012E-25 uc1=5.2148775E-12 luc1=-5.195283211249999E-19 at=6.394335E4 \
    lat=2.4945216175E-3 prt=0 njs=1.2928 xtis=2 \
    tpb=1.2287E-3 tpbsw=0 tpbswg=0 tcj=7.92E-4 \
    tcjsw=1E-5 tcjswg=0 tvoff=0 tvfbsdoff=0 \
    saref=1.1E-6 sbref=1.1E-6 wlod=0 ku0=-2.7E-8 \
    kvsat=0.2 kvth0=7.9E-9 tku0=0 llodku0=0 \
    wlodku0=1 llodvth=0 wlodvth=1 lku0=0 \
    wku0=0 pku0=0 lkvth0=0 wkvth0=3E-7 \
    pkvth0=0 stk2=0 lodk2=1 steta0=0 \
    lodeta0=1 rsh=488.7093023255814

// l=0.15 w=47.3 nf=26 -> bin nlowvt_model.8  rsh=492.4767 delvto=0 (folded into vth0)
model nlowvt_model__w47p3nf26 bsim4 \
    type=n version=4.50 binunit=2 mobmod=0 \
    capmod=2 rdsmod=0 igcmod=0 igbmod=0 \
    rbodymod=1 trnqsmod=0 acnqsmod=0 fnoimod=1 \
    tnoimod=1 diomod=1 tempmod=0 permod=1 \
    geomod=0 rgatemod=0 epsrox=3.9 toxe=4.148E-9 \
    toxm=4.148E-9 dtox=0 xj=1.5E-7 ndep=1.7E17 \
    ngate=9.999999999999999E22 nsd=1E20 rshg=0.1 phin=0 \
    wint=2.6e-08 wl=0 wln=1 ww=0 \
    wwn=1 wwl=0 lint=1.2025e-08 ll=0 \
    lln=1 lw=0 lwn=1 lwl=0 \
    llc=0 lwc=0 lwlc=0 wlc=0 \
    wwc=0 wwlc=0 dwg=-1.33E-8 dwb=-1.08E-8 \
    xl=0 xw=0 dmcg=0 dmdg=0 \
    dmcgt=0 xgw=0 xgl=0 ngcon=1 \
    vth0=0.249959346666667 lvth0=-1.985141612666671E-9 vfb=0 k1=1.011211866666667 \
    lk1=-4.876429660666666E-8 k2=-0.21737859252 lk2=1.7355223637994E-8 k3=1.65 \
    k3b=1.6 w0=1E-7 lpe0=2.3802E-7 lpeb=-4.9152E-8 \
    vbm=-3 dvtp0=0 dvtp1=0 dvt0=0.07665 \
    dvt1=0.1252 dvt2=-0.05637 dvt0w=0 dvt1w=5.3E6 \
    dvt2w=-0.032 vfbsdoff=0 u0=0.01421071555 lu0=2.166698264775001E-10 \
    ua=-3.496851672833332E-9 lua=1.729222681883582E-16 ub=4.57941585E-18 lub=-2.719028563075E-25 \
    uc=1.863698448333334E-10 luc=-2.261771620175834E-17 ud=0 up=0 \
    lp=1 eu=1.67 vsat=1.819855189500001E5 lvsat=-1.786254255252507E-3 \
    a0=0 ags=1.005218833333333 lags=3.096873294166675E-8 b0=0 \
    b1=0 keta=0.1569286063 lketa=-4.276737497598501E-8 a1=0 \
    a2=0.38689047 rdsw=103.65 rdswmin=0 rdw=0 \
    rdwmin=0 rsw=0 rswmin=0 prwb=0 \
    prwg=0 wr=1 voff=-0.11934831869 lvoff=5.296050099455504E-9 \
    voffl=0 minv=0 nfactor=0.723459400166666 lnfactor=3.583940752490084E-7 \
    eta0=0.067637351756667 leta0=1.529144370447834E-9 etab=-0.077077273825 letab=9.70788263825875E-9 \
    dsub=0.58180516425 ldsub=-4.053136043728748E-8 cit=5E-6 cdsc=3.8556E-37 \
    cdscb=-1.1484E-4 cdscd=4.7984E-6 pclm=0.086824416666667 lpclm=9.59179572083335E-9 \
    pdiblc1=3.583688213883334 lpdiblc1=-4.029261769551058E-7 pdiblc2=0.064735802833333 lpdiblc2=-7.957785851858334E-9 \
    pdiblcb=0 drout=3.4946 pscbe1=4.5E8 pscbe2=1E-8 \
    pvag=0 delta=0.01 fprout=0 pdits=1.4427E-15 \
    pditsl=0 pditsd=0 lambda=0 vtl=0 \
    lc=0 xn=0 alpha0=1.687407635666667E-3 lalpha0=-1.627859334572167E-10 \
    alpha1=0 beta0=31.24083182666667 lbeta0=-3.496153888186668E-7 aigbacc=1 \
    bigbacc=0 cigbacc=0 nigbacc=1 aigbinv=0.35 \
    bigbinv=0.03 cigbinv=6E-3 eigbinv=1.1 nigbinv=3 \
    aigc=0.43 bigc=0.054 cigc=0.075 aigsd=0.43 \
    bigsd=0.054 cigsd=0.075 dlcig=0 nigc=1 \
    poxedge=1 pigcd=1 ntox=1 toxref=4.148E-9 \
    agidl=0 bgidl=2.3E9 cgidl=0.5 egidl=0.8 \
    noia=9E41 noib=1E27 noic=8E11 em=4.1E7 \
    af=1 ef=1.2 kf=0 lintnoi=-3E-7 \
    tnoia=2.5E7 tnoib=9.9E6 ntnoi=1 rnoia=0.912 \
    rnoib=0.26 xpart=0 cgso=2.392894381e-10 cgdo=2.392894381e-10 \
    cgbo=1e-14 ckappas=0.6 cf=1E-14 clc=1E-7 \
    cle=0.6 dlc=1.21071E-8 dwc=2.6E-8 vfbcv=-1 \
    noff=3.8661 voffcv=-0.16994 acde=0.38008 moin=23.81 \
    cgsl=2.310725e-11 cgdl=2.310725e-11 ijthsrev=0.1 ijthsfwd=0.1 \
    xjbvs=1 bvs=11.9 jss=2.75E-3 jsws=6E-10 \
    cjs=0.00121 mjs=0.42197 mjsws=1E-3 cjsws=3.230311424e-11 \
    cjswgs=1.795291232e-10 mjswgs=0.8 pbs=0.7477 pbsws=0.1 \
    pbswgs=0.79644 xrcrg1=12 xrcrg2=1 rbpb=50 \
    rbpd=50 rbps=50 rbdb=50 rbsb=50 \
    gbmin=1E-12 tnom=30 ute=-2.841387833333333 lute=1.462012276083332E-7 \
    kt1=-0.295119316666667 lkt1=-2.874265065833337E-9 kt1l=0 kt2=0.02122778 \
    lkt2=-5.743292291000001E-9 ua1=-2.42902207E-9 lua1=3.816539507165E-16 ub1=2.4443796E-18 \
    lub1=-4.0006627012E-25 uc1=5.2148775E-12 luc1=-5.195283211249999E-19 at=6.394335E4 \
    lat=2.4945216175E-3 prt=0 njs=1.2928 xtis=2 \
    tpb=1.2287E-3 tpbsw=0 tpbswg=0 tcj=7.92E-4 \
    tcjsw=1E-5 tcjswg=0 tvoff=0 tvfbsdoff=0 \
    saref=1.1E-6 sbref=1.1E-6 wlod=0 ku0=-2.7E-8 \
    kvsat=0.2 kvth0=7.9E-9 tku0=0 llodku0=0 \
    wlodku0=1 llodvth=0 wlodvth=1 lku0=0 \
    wku0=0 pku0=0 lkvth0=0 wkvth0=3E-7 \
    pkvth0=0 stk2=0 lodk2=1 steta0=0 \
    lodeta0=1 rsh=492.4767441860465

// l=0.15 w=51.3 nf=18 -> bin nlowvt_model.8  rsh=474.7632 delvto=0 (folded into vth0)
model nlowvt_model__w51p3nf18 bsim4 \
    type=n version=4.50 binunit=2 mobmod=0 \
    capmod=2 rdsmod=0 igcmod=0 igbmod=0 \
    rbodymod=1 trnqsmod=0 acnqsmod=0 fnoimod=1 \
    tnoimod=1 diomod=1 tempmod=0 permod=1 \
    geomod=0 rgatemod=0 epsrox=3.9 toxe=4.148E-9 \
    toxm=4.148E-9 dtox=0 xj=1.5E-7 ndep=1.7E17 \
    ngate=9.999999999999999E22 nsd=1E20 rshg=0.1 phin=0 \
    wint=2.6e-08 wl=0 wln=1 ww=0 \
    wwn=1 wwl=0 lint=1.2025e-08 ll=0 \
    lln=1 lw=0 lwn=1 lwl=0 \
    llc=0 lwc=0 lwlc=0 wlc=0 \
    wwc=0 wwlc=0 dwg=-1.33E-8 dwb=-1.08E-8 \
    xl=0 xw=0 dmcg=0 dmdg=0 \
    dmcgt=0 xgw=0 xgl=0 ngcon=1 \
    vth0=0.249959346666667 lvth0=-1.985141612666671E-9 vfb=0 k1=1.011211866666667 \
    lk1=-4.876429660666666E-8 k2=-0.21737859252 lk2=1.7355223637994E-8 k3=1.65 \
    k3b=1.6 w0=1E-7 lpe0=2.3802E-7 lpeb=-4.9152E-8 \
    vbm=-3 dvtp0=0 dvtp1=0 dvt0=0.07665 \
    dvt1=0.1252 dvt2=-0.05637 dvt0w=0 dvt1w=5.3E6 \
    dvt2w=-0.032 vfbsdoff=0 u0=0.01421071555 lu0=2.166698264775001E-10 \
    ua=-3.496851672833332E-9 lua=1.729222681883582E-16 ub=4.57941585E-18 lub=-2.719028563075E-25 \
    uc=1.863698448333334E-10 luc=-2.261771620175834E-17 ud=0 up=0 \
    lp=1 eu=1.67 vsat=1.819855189500001E5 lvsat=-1.786254255252507E-3 \
    a0=0 ags=1.005218833333333 lags=3.096873294166675E-8 b0=0 \
    b1=0 keta=0.1569286063 lketa=-4.276737497598501E-8 a1=0 \
    a2=0.38689047 rdsw=103.65 rdswmin=0 rdw=0 \
    rdwmin=0 rsw=0 rswmin=0 prwb=0 \
    prwg=0 wr=1 voff=-0.11934831869 lvoff=5.296050099455504E-9 \
    voffl=0 minv=0 nfactor=0.723459400166666 lnfactor=3.583940752490084E-7 \
    eta0=0.067637351756667 leta0=1.529144370447834E-9 etab=-0.077077273825 letab=9.70788263825875E-9 \
    dsub=0.58180516425 ldsub=-4.053136043728748E-8 cit=5E-6 cdsc=3.8556E-37 \
    cdscb=-1.1484E-4 cdscd=4.7984E-6 pclm=0.086824416666667 lpclm=9.59179572083335E-9 \
    pdiblc1=3.583688213883334 lpdiblc1=-4.029261769551058E-7 pdiblc2=0.064735802833333 lpdiblc2=-7.957785851858334E-9 \
    pdiblcb=0 drout=3.4946 pscbe1=4.5E8 pscbe2=1E-8 \
    pvag=0 delta=0.01 fprout=0 pdits=1.4427E-15 \
    pditsl=0 pditsd=0 lambda=0 vtl=0 \
    lc=0 xn=0 alpha0=1.687407635666667E-3 lalpha0=-1.627859334572167E-10 \
    alpha1=0 beta0=31.24083182666667 lbeta0=-3.496153888186668E-7 aigbacc=1 \
    bigbacc=0 cigbacc=0 nigbacc=1 aigbinv=0.35 \
    bigbinv=0.03 cigbinv=6E-3 eigbinv=1.1 nigbinv=3 \
    aigc=0.43 bigc=0.054 cigc=0.075 aigsd=0.43 \
    bigsd=0.054 cigsd=0.075 dlcig=0 nigc=1 \
    poxedge=1 pigcd=1 ntox=1 toxref=4.148E-9 \
    agidl=0 bgidl=2.3E9 cgidl=0.5 egidl=0.8 \
    noia=9E41 noib=1E27 noic=8E11 em=4.1E7 \
    af=1 ef=1.2 kf=0 lintnoi=-3E-7 \
    tnoia=2.5E7 tnoib=9.9E6 ntnoi=1 rnoia=0.912 \
    rnoib=0.26 xpart=0 cgso=2.392894381e-10 cgdo=2.392894381e-10 \
    cgbo=1e-14 ckappas=0.6 cf=1E-14 clc=1E-7 \
    cle=0.6 dlc=1.21071E-8 dwc=2.6E-8 vfbcv=-1 \
    noff=3.8661 voffcv=-0.16994 acde=0.38008 moin=23.81 \
    cgsl=2.310725e-11 cgdl=2.310725e-11 ijthsrev=0.1 ijthsfwd=0.1 \
    xjbvs=1 bvs=11.9 jss=2.75E-3 jsws=6E-10 \
    cjs=0.00121 mjs=0.42197 mjsws=1E-3 cjsws=3.230311424e-11 \
    cjswgs=1.795291232e-10 mjswgs=0.8 pbs=0.7477 pbsws=0.1 \
    pbswgs=0.79644 xrcrg1=12 xrcrg2=1 rbpb=50 \
    rbpd=50 rbps=50 rbdb=50 rbsb=50 \
    gbmin=1E-12 tnom=30 ute=-2.841387833333333 lute=1.462012276083332E-7 \
    kt1=-0.295119316666667 lkt1=-2.874265065833337E-9 kt1l=0 kt2=0.02122778 \
    lkt2=-5.743292291000001E-9 ua1=-2.42902207E-9 lua1=3.816539507165E-16 ub1=2.4443796E-18 \
    lub1=-4.0006627012E-25 uc1=5.2148775E-12 luc1=-5.195283211249999E-19 at=6.394335E4 \
    lat=2.4945216175E-3 prt=0 njs=1.2928 xtis=2 \
    tpb=1.2287E-3 tpbsw=0 tpbswg=0 tcj=7.92E-4 \
    tcjsw=1E-5 tcjswg=0 tvoff=0 tvfbsdoff=0 \
    saref=1.1E-6 sbref=1.1E-6 wlod=0 ku0=-2.7E-8 \
    kvsat=0.2 kvth0=7.9E-9 tku0=0 llodku0=0 \
    wlodku0=1 llodvth=0 wlodvth=1 lku0=0 \
    wku0=0 pku0=0 lkvth0=0 wkvth0=3E-7 \
    pkvth0=0 stk2=0 lodk2=1 steta0=0 \
    lodeta0=1 rsh=474.7631578947368

// l=0.15 w=51.3 nf=20 -> bin nlowvt_model.8  rsh=478.2368 delvto=0 (folded into vth0)
model nlowvt_model__w51p3nf20 bsim4 \
    type=n version=4.50 binunit=2 mobmod=0 \
    capmod=2 rdsmod=0 igcmod=0 igbmod=0 \
    rbodymod=1 trnqsmod=0 acnqsmod=0 fnoimod=1 \
    tnoimod=1 diomod=1 tempmod=0 permod=1 \
    geomod=0 rgatemod=0 epsrox=3.9 toxe=4.148E-9 \
    toxm=4.148E-9 dtox=0 xj=1.5E-7 ndep=1.7E17 \
    ngate=9.999999999999999E22 nsd=1E20 rshg=0.1 phin=0 \
    wint=2.6e-08 wl=0 wln=1 ww=0 \
    wwn=1 wwl=0 lint=1.2025e-08 ll=0 \
    lln=1 lw=0 lwn=1 lwl=0 \
    llc=0 lwc=0 lwlc=0 wlc=0 \
    wwc=0 wwlc=0 dwg=-1.33E-8 dwb=-1.08E-8 \
    xl=0 xw=0 dmcg=0 dmdg=0 \
    dmcgt=0 xgw=0 xgl=0 ngcon=1 \
    vth0=0.249959346666667 lvth0=-1.985141612666671E-9 vfb=0 k1=1.011211866666667 \
    lk1=-4.876429660666666E-8 k2=-0.21737859252 lk2=1.7355223637994E-8 k3=1.65 \
    k3b=1.6 w0=1E-7 lpe0=2.3802E-7 lpeb=-4.9152E-8 \
    vbm=-3 dvtp0=0 dvtp1=0 dvt0=0.07665 \
    dvt1=0.1252 dvt2=-0.05637 dvt0w=0 dvt1w=5.3E6 \
    dvt2w=-0.032 vfbsdoff=0 u0=0.01421071555 lu0=2.166698264775001E-10 \
    ua=-3.496851672833332E-9 lua=1.729222681883582E-16 ub=4.57941585E-18 lub=-2.719028563075E-25 \
    uc=1.863698448333334E-10 luc=-2.261771620175834E-17 ud=0 up=0 \
    lp=1 eu=1.67 vsat=1.819855189500001E5 lvsat=-1.786254255252507E-3 \
    a0=0 ags=1.005218833333333 lags=3.096873294166675E-8 b0=0 \
    b1=0 keta=0.1569286063 lketa=-4.276737497598501E-8 a1=0 \
    a2=0.38689047 rdsw=103.65 rdswmin=0 rdw=0 \
    rdwmin=0 rsw=0 rswmin=0 prwb=0 \
    prwg=0 wr=1 voff=-0.11934831869 lvoff=5.296050099455504E-9 \
    voffl=0 minv=0 nfactor=0.723459400166666 lnfactor=3.583940752490084E-7 \
    eta0=0.067637351756667 leta0=1.529144370447834E-9 etab=-0.077077273825 letab=9.70788263825875E-9 \
    dsub=0.58180516425 ldsub=-4.053136043728748E-8 cit=5E-6 cdsc=3.8556E-37 \
    cdscb=-1.1484E-4 cdscd=4.7984E-6 pclm=0.086824416666667 lpclm=9.59179572083335E-9 \
    pdiblc1=3.583688213883334 lpdiblc1=-4.029261769551058E-7 pdiblc2=0.064735802833333 lpdiblc2=-7.957785851858334E-9 \
    pdiblcb=0 drout=3.4946 pscbe1=4.5E8 pscbe2=1E-8 \
    pvag=0 delta=0.01 fprout=0 pdits=1.4427E-15 \
    pditsl=0 pditsd=0 lambda=0 vtl=0 \
    lc=0 xn=0 alpha0=1.687407635666667E-3 lalpha0=-1.627859334572167E-10 \
    alpha1=0 beta0=31.24083182666667 lbeta0=-3.496153888186668E-7 aigbacc=1 \
    bigbacc=0 cigbacc=0 nigbacc=1 aigbinv=0.35 \
    bigbinv=0.03 cigbinv=6E-3 eigbinv=1.1 nigbinv=3 \
    aigc=0.43 bigc=0.054 cigc=0.075 aigsd=0.43 \
    bigsd=0.054 cigsd=0.075 dlcig=0 nigc=1 \
    poxedge=1 pigcd=1 ntox=1 toxref=4.148E-9 \
    agidl=0 bgidl=2.3E9 cgidl=0.5 egidl=0.8 \
    noia=9E41 noib=1E27 noic=8E11 em=4.1E7 \
    af=1 ef=1.2 kf=0 lintnoi=-3E-7 \
    tnoia=2.5E7 tnoib=9.9E6 ntnoi=1 rnoia=0.912 \
    rnoib=0.26 xpart=0 cgso=2.392894381e-10 cgdo=2.392894381e-10 \
    cgbo=1e-14 ckappas=0.6 cf=1E-14 clc=1E-7 \
    cle=0.6 dlc=1.21071E-8 dwc=2.6E-8 vfbcv=-1 \
    noff=3.8661 voffcv=-0.16994 acde=0.38008 moin=23.81 \
    cgsl=2.310725e-11 cgdl=2.310725e-11 ijthsrev=0.1 ijthsfwd=0.1 \
    xjbvs=1 bvs=11.9 jss=2.75E-3 jsws=6E-10 \
    cjs=0.00121 mjs=0.42197 mjsws=1E-3 cjsws=3.230311424e-11 \
    cjswgs=1.795291232e-10 mjswgs=0.8 pbs=0.7477 pbsws=0.1 \
    pbswgs=0.79644 xrcrg1=12 xrcrg2=1 rbpb=50 \
    rbpd=50 rbps=50 rbdb=50 rbsb=50 \
    gbmin=1E-12 tnom=30 ute=-2.841387833333333 lute=1.462012276083332E-7 \
    kt1=-0.295119316666667 lkt1=-2.874265065833337E-9 kt1l=0 kt2=0.02122778 \
    lkt2=-5.743292291000001E-9 ua1=-2.42902207E-9 lua1=3.816539507165E-16 ub1=2.4443796E-18 \
    lub1=-4.0006627012E-25 uc1=5.2148775E-12 luc1=-5.195283211249999E-19 at=6.394335E4 \
    lat=2.4945216175E-3 prt=0 njs=1.2928 xtis=2 \
    tpb=1.2287E-3 tpbsw=0 tpbswg=0 tcj=7.92E-4 \
    tcjsw=1E-5 tcjswg=0 tvoff=0 tvfbsdoff=0 \
    saref=1.1E-6 sbref=1.1E-6 wlod=0 ku0=-2.7E-8 \
    kvsat=0.2 kvth0=7.9E-9 tku0=0 llodku0=0 \
    wlodku0=1 llodvth=0 wlodvth=1 lku0=0 \
    wku0=0 pku0=0 lkvth0=0 wkvth0=3E-7 \
    pkvth0=0 stk2=0 lodk2=1 steta0=0 \
    lodeta0=1 rsh=478.2368421052632

// l=0.15 w=51.3 nf=22 -> bin nlowvt_model.8  rsh=481.7105 delvto=0 (folded into vth0)
model nlowvt_model__w51p3nf22 bsim4 \
    type=n version=4.50 binunit=2 mobmod=0 \
    capmod=2 rdsmod=0 igcmod=0 igbmod=0 \
    rbodymod=1 trnqsmod=0 acnqsmod=0 fnoimod=1 \
    tnoimod=1 diomod=1 tempmod=0 permod=1 \
    geomod=0 rgatemod=0 epsrox=3.9 toxe=4.148E-9 \
    toxm=4.148E-9 dtox=0 xj=1.5E-7 ndep=1.7E17 \
    ngate=9.999999999999999E22 nsd=1E20 rshg=0.1 phin=0 \
    wint=2.6e-08 wl=0 wln=1 ww=0 \
    wwn=1 wwl=0 lint=1.2025e-08 ll=0 \
    lln=1 lw=0 lwn=1 lwl=0 \
    llc=0 lwc=0 lwlc=0 wlc=0 \
    wwc=0 wwlc=0 dwg=-1.33E-8 dwb=-1.08E-8 \
    xl=0 xw=0 dmcg=0 dmdg=0 \
    dmcgt=0 xgw=0 xgl=0 ngcon=1 \
    vth0=0.249959346666667 lvth0=-1.985141612666671E-9 vfb=0 k1=1.011211866666667 \
    lk1=-4.876429660666666E-8 k2=-0.21737859252 lk2=1.7355223637994E-8 k3=1.65 \
    k3b=1.6 w0=1E-7 lpe0=2.3802E-7 lpeb=-4.9152E-8 \
    vbm=-3 dvtp0=0 dvtp1=0 dvt0=0.07665 \
    dvt1=0.1252 dvt2=-0.05637 dvt0w=0 dvt1w=5.3E6 \
    dvt2w=-0.032 vfbsdoff=0 u0=0.01421071555 lu0=2.166698264775001E-10 \
    ua=-3.496851672833332E-9 lua=1.729222681883582E-16 ub=4.57941585E-18 lub=-2.719028563075E-25 \
    uc=1.863698448333334E-10 luc=-2.261771620175834E-17 ud=0 up=0 \
    lp=1 eu=1.67 vsat=1.819855189500001E5 lvsat=-1.786254255252507E-3 \
    a0=0 ags=1.005218833333333 lags=3.096873294166675E-8 b0=0 \
    b1=0 keta=0.1569286063 lketa=-4.276737497598501E-8 a1=0 \
    a2=0.38689047 rdsw=103.65 rdswmin=0 rdw=0 \
    rdwmin=0 rsw=0 rswmin=0 prwb=0 \
    prwg=0 wr=1 voff=-0.11934831869 lvoff=5.296050099455504E-9 \
    voffl=0 minv=0 nfactor=0.723459400166666 lnfactor=3.583940752490084E-7 \
    eta0=0.067637351756667 leta0=1.529144370447834E-9 etab=-0.077077273825 letab=9.70788263825875E-9 \
    dsub=0.58180516425 ldsub=-4.053136043728748E-8 cit=5E-6 cdsc=3.8556E-37 \
    cdscb=-1.1484E-4 cdscd=4.7984E-6 pclm=0.086824416666667 lpclm=9.59179572083335E-9 \
    pdiblc1=3.583688213883334 lpdiblc1=-4.029261769551058E-7 pdiblc2=0.064735802833333 lpdiblc2=-7.957785851858334E-9 \
    pdiblcb=0 drout=3.4946 pscbe1=4.5E8 pscbe2=1E-8 \
    pvag=0 delta=0.01 fprout=0 pdits=1.4427E-15 \
    pditsl=0 pditsd=0 lambda=0 vtl=0 \
    lc=0 xn=0 alpha0=1.687407635666667E-3 lalpha0=-1.627859334572167E-10 \
    alpha1=0 beta0=31.24083182666667 lbeta0=-3.496153888186668E-7 aigbacc=1 \
    bigbacc=0 cigbacc=0 nigbacc=1 aigbinv=0.35 \
    bigbinv=0.03 cigbinv=6E-3 eigbinv=1.1 nigbinv=3 \
    aigc=0.43 bigc=0.054 cigc=0.075 aigsd=0.43 \
    bigsd=0.054 cigsd=0.075 dlcig=0 nigc=1 \
    poxedge=1 pigcd=1 ntox=1 toxref=4.148E-9 \
    agidl=0 bgidl=2.3E9 cgidl=0.5 egidl=0.8 \
    noia=9E41 noib=1E27 noic=8E11 em=4.1E7 \
    af=1 ef=1.2 kf=0 lintnoi=-3E-7 \
    tnoia=2.5E7 tnoib=9.9E6 ntnoi=1 rnoia=0.912 \
    rnoib=0.26 xpart=0 cgso=2.392894381e-10 cgdo=2.392894381e-10 \
    cgbo=1e-14 ckappas=0.6 cf=1E-14 clc=1E-7 \
    cle=0.6 dlc=1.21071E-8 dwc=2.6E-8 vfbcv=-1 \
    noff=3.8661 voffcv=-0.16994 acde=0.38008 moin=23.81 \
    cgsl=2.310725e-11 cgdl=2.310725e-11 ijthsrev=0.1 ijthsfwd=0.1 \
    xjbvs=1 bvs=11.9 jss=2.75E-3 jsws=6E-10 \
    cjs=0.00121 mjs=0.42197 mjsws=1E-3 cjsws=3.230311424e-11 \
    cjswgs=1.795291232e-10 mjswgs=0.8 pbs=0.7477 pbsws=0.1 \
    pbswgs=0.79644 xrcrg1=12 xrcrg2=1 rbpb=50 \
    rbpd=50 rbps=50 rbdb=50 rbsb=50 \
    gbmin=1E-12 tnom=30 ute=-2.841387833333333 lute=1.462012276083332E-7 \
    kt1=-0.295119316666667 lkt1=-2.874265065833337E-9 kt1l=0 kt2=0.02122778 \
    lkt2=-5.743292291000001E-9 ua1=-2.42902207E-9 lua1=3.816539507165E-16 ub1=2.4443796E-18 \
    lub1=-4.0006627012E-25 uc1=5.2148775E-12 luc1=-5.195283211249999E-19 at=6.394335E4 \
    lat=2.4945216175E-3 prt=0 njs=1.2928 xtis=2 \
    tpb=1.2287E-3 tpbsw=0 tpbswg=0 tcj=7.92E-4 \
    tcjsw=1E-5 tcjswg=0 tvoff=0 tvfbsdoff=0 \
    saref=1.1E-6 sbref=1.1E-6 wlod=0 ku0=-2.7E-8 \
    kvsat=0.2 kvth0=7.9E-9 tku0=0 llodku0=0 \
    wlodku0=1 llodvth=0 wlodvth=1 lku0=0 \
    wku0=0 pku0=0 lkvth0=0 wkvth0=3E-7 \
    pkvth0=0 stk2=0 lodk2=1 steta0=0 \
    lodeta0=1 rsh=481.7105263157895

// l=0.15 w=51.3 nf=24 -> bin nlowvt_model.8  rsh=485.1842 delvto=0 (folded into vth0)
model nlowvt_model__w51p3nf24 bsim4 \
    type=n version=4.50 binunit=2 mobmod=0 \
    capmod=2 rdsmod=0 igcmod=0 igbmod=0 \
    rbodymod=1 trnqsmod=0 acnqsmod=0 fnoimod=1 \
    tnoimod=1 diomod=1 tempmod=0 permod=1 \
    geomod=0 rgatemod=0 epsrox=3.9 toxe=4.148E-9 \
    toxm=4.148E-9 dtox=0 xj=1.5E-7 ndep=1.7E17 \
    ngate=9.999999999999999E22 nsd=1E20 rshg=0.1 phin=0 \
    wint=2.6e-08 wl=0 wln=1 ww=0 \
    wwn=1 wwl=0 lint=1.2025e-08 ll=0 \
    lln=1 lw=0 lwn=1 lwl=0 \
    llc=0 lwc=0 lwlc=0 wlc=0 \
    wwc=0 wwlc=0 dwg=-1.33E-8 dwb=-1.08E-8 \
    xl=0 xw=0 dmcg=0 dmdg=0 \
    dmcgt=0 xgw=0 xgl=0 ngcon=1 \
    vth0=0.249959346666667 lvth0=-1.985141612666671E-9 vfb=0 k1=1.011211866666667 \
    lk1=-4.876429660666666E-8 k2=-0.21737859252 lk2=1.7355223637994E-8 k3=1.65 \
    k3b=1.6 w0=1E-7 lpe0=2.3802E-7 lpeb=-4.9152E-8 \
    vbm=-3 dvtp0=0 dvtp1=0 dvt0=0.07665 \
    dvt1=0.1252 dvt2=-0.05637 dvt0w=0 dvt1w=5.3E6 \
    dvt2w=-0.032 vfbsdoff=0 u0=0.01421071555 lu0=2.166698264775001E-10 \
    ua=-3.496851672833332E-9 lua=1.729222681883582E-16 ub=4.57941585E-18 lub=-2.719028563075E-25 \
    uc=1.863698448333334E-10 luc=-2.261771620175834E-17 ud=0 up=0 \
    lp=1 eu=1.67 vsat=1.819855189500001E5 lvsat=-1.786254255252507E-3 \
    a0=0 ags=1.005218833333333 lags=3.096873294166675E-8 b0=0 \
    b1=0 keta=0.1569286063 lketa=-4.276737497598501E-8 a1=0 \
    a2=0.38689047 rdsw=103.65 rdswmin=0 rdw=0 \
    rdwmin=0 rsw=0 rswmin=0 prwb=0 \
    prwg=0 wr=1 voff=-0.11934831869 lvoff=5.296050099455504E-9 \
    voffl=0 minv=0 nfactor=0.723459400166666 lnfactor=3.583940752490084E-7 \
    eta0=0.067637351756667 leta0=1.529144370447834E-9 etab=-0.077077273825 letab=9.70788263825875E-9 \
    dsub=0.58180516425 ldsub=-4.053136043728748E-8 cit=5E-6 cdsc=3.8556E-37 \
    cdscb=-1.1484E-4 cdscd=4.7984E-6 pclm=0.086824416666667 lpclm=9.59179572083335E-9 \
    pdiblc1=3.583688213883334 lpdiblc1=-4.029261769551058E-7 pdiblc2=0.064735802833333 lpdiblc2=-7.957785851858334E-9 \
    pdiblcb=0 drout=3.4946 pscbe1=4.5E8 pscbe2=1E-8 \
    pvag=0 delta=0.01 fprout=0 pdits=1.4427E-15 \
    pditsl=0 pditsd=0 lambda=0 vtl=0 \
    lc=0 xn=0 alpha0=1.687407635666667E-3 lalpha0=-1.627859334572167E-10 \
    alpha1=0 beta0=31.24083182666667 lbeta0=-3.496153888186668E-7 aigbacc=1 \
    bigbacc=0 cigbacc=0 nigbacc=1 aigbinv=0.35 \
    bigbinv=0.03 cigbinv=6E-3 eigbinv=1.1 nigbinv=3 \
    aigc=0.43 bigc=0.054 cigc=0.075 aigsd=0.43 \
    bigsd=0.054 cigsd=0.075 dlcig=0 nigc=1 \
    poxedge=1 pigcd=1 ntox=1 toxref=4.148E-9 \
    agidl=0 bgidl=2.3E9 cgidl=0.5 egidl=0.8 \
    noia=9E41 noib=1E27 noic=8E11 em=4.1E7 \
    af=1 ef=1.2 kf=0 lintnoi=-3E-7 \
    tnoia=2.5E7 tnoib=9.9E6 ntnoi=1 rnoia=0.912 \
    rnoib=0.26 xpart=0 cgso=2.392894381e-10 cgdo=2.392894381e-10 \
    cgbo=1e-14 ckappas=0.6 cf=1E-14 clc=1E-7 \
    cle=0.6 dlc=1.21071E-8 dwc=2.6E-8 vfbcv=-1 \
    noff=3.8661 voffcv=-0.16994 acde=0.38008 moin=23.81 \
    cgsl=2.310725e-11 cgdl=2.310725e-11 ijthsrev=0.1 ijthsfwd=0.1 \
    xjbvs=1 bvs=11.9 jss=2.75E-3 jsws=6E-10 \
    cjs=0.00121 mjs=0.42197 mjsws=1E-3 cjsws=3.230311424e-11 \
    cjswgs=1.795291232e-10 mjswgs=0.8 pbs=0.7477 pbsws=0.1 \
    pbswgs=0.79644 xrcrg1=12 xrcrg2=1 rbpb=50 \
    rbpd=50 rbps=50 rbdb=50 rbsb=50 \
    gbmin=1E-12 tnom=30 ute=-2.841387833333333 lute=1.462012276083332E-7 \
    kt1=-0.295119316666667 lkt1=-2.874265065833337E-9 kt1l=0 kt2=0.02122778 \
    lkt2=-5.743292291000001E-9 ua1=-2.42902207E-9 lua1=3.816539507165E-16 ub1=2.4443796E-18 \
    lub1=-4.0006627012E-25 uc1=5.2148775E-12 luc1=-5.195283211249999E-19 at=6.394335E4 \
    lat=2.4945216175E-3 prt=0 njs=1.2928 xtis=2 \
    tpb=1.2287E-3 tpbsw=0 tpbswg=0 tcj=7.92E-4 \
    tcjsw=1E-5 tcjswg=0 tvoff=0 tvfbsdoff=0 \
    saref=1.1E-6 sbref=1.1E-6 wlod=0 ku0=-2.7E-8 \
    kvsat=0.2 kvth0=7.9E-9 tku0=0 llodku0=0 \
    wlodku0=1 llodvth=0 wlodvth=1 lku0=0 \
    wku0=0 pku0=0 lkvth0=0 wkvth0=3E-7 \
    pkvth0=0 stk2=0 lodk2=1 steta0=0 \
    lodeta0=1 rsh=485.1842105263158

// l=0.15 w=51.3 nf=26 -> bin nlowvt_model.8  rsh=488.6579 delvto=0 (folded into vth0)
model nlowvt_model__w51p3nf26 bsim4 \
    type=n version=4.50 binunit=2 mobmod=0 \
    capmod=2 rdsmod=0 igcmod=0 igbmod=0 \
    rbodymod=1 trnqsmod=0 acnqsmod=0 fnoimod=1 \
    tnoimod=1 diomod=1 tempmod=0 permod=1 \
    geomod=0 rgatemod=0 epsrox=3.9 toxe=4.148E-9 \
    toxm=4.148E-9 dtox=0 xj=1.5E-7 ndep=1.7E17 \
    ngate=9.999999999999999E22 nsd=1E20 rshg=0.1 phin=0 \
    wint=2.6e-08 wl=0 wln=1 ww=0 \
    wwn=1 wwl=0 lint=1.2025e-08 ll=0 \
    lln=1 lw=0 lwn=1 lwl=0 \
    llc=0 lwc=0 lwlc=0 wlc=0 \
    wwc=0 wwlc=0 dwg=-1.33E-8 dwb=-1.08E-8 \
    xl=0 xw=0 dmcg=0 dmdg=0 \
    dmcgt=0 xgw=0 xgl=0 ngcon=1 \
    vth0=0.249959346666667 lvth0=-1.985141612666671E-9 vfb=0 k1=1.011211866666667 \
    lk1=-4.876429660666666E-8 k2=-0.21737859252 lk2=1.7355223637994E-8 k3=1.65 \
    k3b=1.6 w0=1E-7 lpe0=2.3802E-7 lpeb=-4.9152E-8 \
    vbm=-3 dvtp0=0 dvtp1=0 dvt0=0.07665 \
    dvt1=0.1252 dvt2=-0.05637 dvt0w=0 dvt1w=5.3E6 \
    dvt2w=-0.032 vfbsdoff=0 u0=0.01421071555 lu0=2.166698264775001E-10 \
    ua=-3.496851672833332E-9 lua=1.729222681883582E-16 ub=4.57941585E-18 lub=-2.719028563075E-25 \
    uc=1.863698448333334E-10 luc=-2.261771620175834E-17 ud=0 up=0 \
    lp=1 eu=1.67 vsat=1.819855189500001E5 lvsat=-1.786254255252507E-3 \
    a0=0 ags=1.005218833333333 lags=3.096873294166675E-8 b0=0 \
    b1=0 keta=0.1569286063 lketa=-4.276737497598501E-8 a1=0 \
    a2=0.38689047 rdsw=103.65 rdswmin=0 rdw=0 \
    rdwmin=0 rsw=0 rswmin=0 prwb=0 \
    prwg=0 wr=1 voff=-0.11934831869 lvoff=5.296050099455504E-9 \
    voffl=0 minv=0 nfactor=0.723459400166666 lnfactor=3.583940752490084E-7 \
    eta0=0.067637351756667 leta0=1.529144370447834E-9 etab=-0.077077273825 letab=9.70788263825875E-9 \
    dsub=0.58180516425 ldsub=-4.053136043728748E-8 cit=5E-6 cdsc=3.8556E-37 \
    cdscb=-1.1484E-4 cdscd=4.7984E-6 pclm=0.086824416666667 lpclm=9.59179572083335E-9 \
    pdiblc1=3.583688213883334 lpdiblc1=-4.029261769551058E-7 pdiblc2=0.064735802833333 lpdiblc2=-7.957785851858334E-9 \
    pdiblcb=0 drout=3.4946 pscbe1=4.5E8 pscbe2=1E-8 \
    pvag=0 delta=0.01 fprout=0 pdits=1.4427E-15 \
    pditsl=0 pditsd=0 lambda=0 vtl=0 \
    lc=0 xn=0 alpha0=1.687407635666667E-3 lalpha0=-1.627859334572167E-10 \
    alpha1=0 beta0=31.24083182666667 lbeta0=-3.496153888186668E-7 aigbacc=1 \
    bigbacc=0 cigbacc=0 nigbacc=1 aigbinv=0.35 \
    bigbinv=0.03 cigbinv=6E-3 eigbinv=1.1 nigbinv=3 \
    aigc=0.43 bigc=0.054 cigc=0.075 aigsd=0.43 \
    bigsd=0.054 cigsd=0.075 dlcig=0 nigc=1 \
    poxedge=1 pigcd=1 ntox=1 toxref=4.148E-9 \
    agidl=0 bgidl=2.3E9 cgidl=0.5 egidl=0.8 \
    noia=9E41 noib=1E27 noic=8E11 em=4.1E7 \
    af=1 ef=1.2 kf=0 lintnoi=-3E-7 \
    tnoia=2.5E7 tnoib=9.9E6 ntnoi=1 rnoia=0.912 \
    rnoib=0.26 xpart=0 cgso=2.392894381e-10 cgdo=2.392894381e-10 \
    cgbo=1e-14 ckappas=0.6 cf=1E-14 clc=1E-7 \
    cle=0.6 dlc=1.21071E-8 dwc=2.6E-8 vfbcv=-1 \
    noff=3.8661 voffcv=-0.16994 acde=0.38008 moin=23.81 \
    cgsl=2.310725e-11 cgdl=2.310725e-11 ijthsrev=0.1 ijthsfwd=0.1 \
    xjbvs=1 bvs=11.9 jss=2.75E-3 jsws=6E-10 \
    cjs=0.00121 mjs=0.42197 mjsws=1E-3 cjsws=3.230311424e-11 \
    cjswgs=1.795291232e-10 mjswgs=0.8 pbs=0.7477 pbsws=0.1 \
    pbswgs=0.79644 xrcrg1=12 xrcrg2=1 rbpb=50 \
    rbpd=50 rbps=50 rbdb=50 rbsb=50 \
    gbmin=1E-12 tnom=30 ute=-2.841387833333333 lute=1.462012276083332E-7 \
    kt1=-0.295119316666667 lkt1=-2.874265065833337E-9 kt1l=0 kt2=0.02122778 \
    lkt2=-5.743292291000001E-9 ua1=-2.42902207E-9 lua1=3.816539507165E-16 ub1=2.4443796E-18 \
    lub1=-4.0006627012E-25 uc1=5.2148775E-12 luc1=-5.195283211249999E-19 at=6.394335E4 \
    lat=2.4945216175E-3 prt=0 njs=1.2928 xtis=2 \
    tpb=1.2287E-3 tpbsw=0 tpbswg=0 tcj=7.92E-4 \
    tcjsw=1E-5 tcjswg=0 tvoff=0 tvfbsdoff=0 \
    saref=1.1E-6 sbref=1.1E-6 wlod=0 ku0=-2.7E-8 \
    kvsat=0.2 kvth0=7.9E-9 tku0=0 llodku0=0 \
    wlodku0=1 llodvth=0 wlodvth=1 lku0=0 \
    wku0=0 pku0=0 lkvth0=0 wkvth0=3E-7 \
    pkvth0=0 stk2=0 lodk2=1 steta0=0 \
    lodeta0=1 rsh=488.6578947368421

// l=0.15 w=53.7 nf=27 -> bin nlowvt_model.8  rsh=488.2989 delvto=0 (folded into vth0)
model nlowvt_model__w53p7nf27 bsim4 \
    type=n version=4.50 binunit=2 mobmod=0 \
    capmod=2 rdsmod=0 igcmod=0 igbmod=0 \
    rbodymod=1 trnqsmod=0 acnqsmod=0 fnoimod=1 \
    tnoimod=1 diomod=1 tempmod=0 permod=1 \
    geomod=0 rgatemod=0 epsrox=3.9 toxe=4.148E-9 \
    toxm=4.148E-9 dtox=0 xj=1.5E-7 ndep=1.7E17 \
    ngate=9.999999999999999E22 nsd=1E20 rshg=0.1 phin=0 \
    wint=2.6e-08 wl=0 wln=1 ww=0 \
    wwn=1 wwl=0 lint=1.2025e-08 ll=0 \
    lln=1 lw=0 lwn=1 lwl=0 \
    llc=0 lwc=0 lwlc=0 wlc=0 \
    wwc=0 wwlc=0 dwg=-1.33E-8 dwb=-1.08E-8 \
    xl=0 xw=0 dmcg=0 dmdg=0 \
    dmcgt=0 xgw=0 xgl=0 ngcon=1 \
    vth0=0.249959346666667 lvth0=-1.985141612666671E-9 vfb=0 k1=1.011211866666667 \
    lk1=-4.876429660666666E-8 k2=-0.21737859252 lk2=1.7355223637994E-8 k3=1.65 \
    k3b=1.6 w0=1E-7 lpe0=2.3802E-7 lpeb=-4.9152E-8 \
    vbm=-3 dvtp0=0 dvtp1=0 dvt0=0.07665 \
    dvt1=0.1252 dvt2=-0.05637 dvt0w=0 dvt1w=5.3E6 \
    dvt2w=-0.032 vfbsdoff=0 u0=0.01421071555 lu0=2.166698264775001E-10 \
    ua=-3.496851672833332E-9 lua=1.729222681883582E-16 ub=4.57941585E-18 lub=-2.719028563075E-25 \
    uc=1.863698448333334E-10 luc=-2.261771620175834E-17 ud=0 up=0 \
    lp=1 eu=1.67 vsat=1.819855189500001E5 lvsat=-1.786254255252507E-3 \
    a0=0 ags=1.005218833333333 lags=3.096873294166675E-8 b0=0 \
    b1=0 keta=0.1569286063 lketa=-4.276737497598501E-8 a1=0 \
    a2=0.38689047 rdsw=103.65 rdswmin=0 rdw=0 \
    rdwmin=0 rsw=0 rswmin=0 prwb=0 \
    prwg=0 wr=1 voff=-0.11934831869 lvoff=5.296050099455504E-9 \
    voffl=0 minv=0 nfactor=0.723459400166666 lnfactor=3.583940752490084E-7 \
    eta0=0.067637351756667 leta0=1.529144370447834E-9 etab=-0.077077273825 letab=9.70788263825875E-9 \
    dsub=0.58180516425 ldsub=-4.053136043728748E-8 cit=5E-6 cdsc=3.8556E-37 \
    cdscb=-1.1484E-4 cdscd=4.7984E-6 pclm=0.086824416666667 lpclm=9.59179572083335E-9 \
    pdiblc1=3.583688213883334 lpdiblc1=-4.029261769551058E-7 pdiblc2=0.064735802833333 lpdiblc2=-7.957785851858334E-9 \
    pdiblcb=0 drout=3.4946 pscbe1=4.5E8 pscbe2=1E-8 \
    pvag=0 delta=0.01 fprout=0 pdits=1.4427E-15 \
    pditsl=0 pditsd=0 lambda=0 vtl=0 \
    lc=0 xn=0 alpha0=1.687407635666667E-3 lalpha0=-1.627859334572167E-10 \
    alpha1=0 beta0=31.24083182666667 lbeta0=-3.496153888186668E-7 aigbacc=1 \
    bigbacc=0 cigbacc=0 nigbacc=1 aigbinv=0.35 \
    bigbinv=0.03 cigbinv=6E-3 eigbinv=1.1 nigbinv=3 \
    aigc=0.43 bigc=0.054 cigc=0.075 aigsd=0.43 \
    bigsd=0.054 cigsd=0.075 dlcig=0 nigc=1 \
    poxedge=1 pigcd=1 ntox=1 toxref=4.148E-9 \
    agidl=0 bgidl=2.3E9 cgidl=0.5 egidl=0.8 \
    noia=9E41 noib=1E27 noic=8E11 em=4.1E7 \
    af=1 ef=1.2 kf=0 lintnoi=-3E-7 \
    tnoia=2.5E7 tnoib=9.9E6 ntnoi=1 rnoia=0.912 \
    rnoib=0.26 xpart=0 cgso=2.392894381e-10 cgdo=2.392894381e-10 \
    cgbo=1e-14 ckappas=0.6 cf=1E-14 clc=1E-7 \
    cle=0.6 dlc=1.21071E-8 dwc=2.6E-8 vfbcv=-1 \
    noff=3.8661 voffcv=-0.16994 acde=0.38008 moin=23.81 \
    cgsl=2.310725e-11 cgdl=2.310725e-11 ijthsrev=0.1 ijthsfwd=0.1 \
    xjbvs=1 bvs=11.9 jss=2.75E-3 jsws=6E-10 \
    cjs=0.00121 mjs=0.42197 mjsws=1E-3 cjsws=3.230311424e-11 \
    cjswgs=1.795291232e-10 mjswgs=0.8 pbs=0.7477 pbsws=0.1 \
    pbswgs=0.79644 xrcrg1=12 xrcrg2=1 rbpb=50 \
    rbpd=50 rbps=50 rbdb=50 rbsb=50 \
    gbmin=1E-12 tnom=30 ute=-2.841387833333333 lute=1.462012276083332E-7 \
    kt1=-0.295119316666667 lkt1=-2.874265065833337E-9 kt1l=0 kt2=0.02122778 \
    lkt2=-5.743292291000001E-9 ua1=-2.42902207E-9 lua1=3.816539507165E-16 ub1=2.4443796E-18 \
    lub1=-4.0006627012E-25 uc1=5.2148775E-12 luc1=-5.195283211249999E-19 at=6.394335E4 \
    lat=2.4945216175E-3 prt=0 njs=1.2928 xtis=2 \
    tpb=1.2287E-3 tpbsw=0 tpbswg=0 tcj=7.92E-4 \
    tcjsw=1E-5 tcjswg=0 tvoff=0 tvfbsdoff=0 \
    saref=1.1E-6 sbref=1.1E-6 wlod=0 ku0=-2.7E-8 \
    kvsat=0.2 kvth0=7.9E-9 tku0=0 llodku0=0 \
    wlodku0=1 llodvth=0 wlodvth=1 lku0=0 \
    wku0=0 pku0=0 lkvth0=0 wkvth0=3E-7 \
    pkvth0=0 stk2=0 lodk2=1 steta0=0 \
    lodeta0=1 rsh=488.29888268156424

// l=0.15 w=53.7 nf=29 -> bin nlowvt_model.8  rsh=491.6173 delvto=0 (folded into vth0)
model nlowvt_model__w53p7nf29 bsim4 \
    type=n version=4.50 binunit=2 mobmod=0 \
    capmod=2 rdsmod=0 igcmod=0 igbmod=0 \
    rbodymod=1 trnqsmod=0 acnqsmod=0 fnoimod=1 \
    tnoimod=1 diomod=1 tempmod=0 permod=1 \
    geomod=0 rgatemod=0 epsrox=3.9 toxe=4.148E-9 \
    toxm=4.148E-9 dtox=0 xj=1.5E-7 ndep=1.7E17 \
    ngate=9.999999999999999E22 nsd=1E20 rshg=0.1 phin=0 \
    wint=2.6e-08 wl=0 wln=1 ww=0 \
    wwn=1 wwl=0 lint=1.2025e-08 ll=0 \
    lln=1 lw=0 lwn=1 lwl=0 \
    llc=0 lwc=0 lwlc=0 wlc=0 \
    wwc=0 wwlc=0 dwg=-1.33E-8 dwb=-1.08E-8 \
    xl=0 xw=0 dmcg=0 dmdg=0 \
    dmcgt=0 xgw=0 xgl=0 ngcon=1 \
    vth0=0.249959346666667 lvth0=-1.985141612666671E-9 vfb=0 k1=1.011211866666667 \
    lk1=-4.876429660666666E-8 k2=-0.21737859252 lk2=1.7355223637994E-8 k3=1.65 \
    k3b=1.6 w0=1E-7 lpe0=2.3802E-7 lpeb=-4.9152E-8 \
    vbm=-3 dvtp0=0 dvtp1=0 dvt0=0.07665 \
    dvt1=0.1252 dvt2=-0.05637 dvt0w=0 dvt1w=5.3E6 \
    dvt2w=-0.032 vfbsdoff=0 u0=0.01421071555 lu0=2.166698264775001E-10 \
    ua=-3.496851672833332E-9 lua=1.729222681883582E-16 ub=4.57941585E-18 lub=-2.719028563075E-25 \
    uc=1.863698448333334E-10 luc=-2.261771620175834E-17 ud=0 up=0 \
    lp=1 eu=1.67 vsat=1.819855189500001E5 lvsat=-1.786254255252507E-3 \
    a0=0 ags=1.005218833333333 lags=3.096873294166675E-8 b0=0 \
    b1=0 keta=0.1569286063 lketa=-4.276737497598501E-8 a1=0 \
    a2=0.38689047 rdsw=103.65 rdswmin=0 rdw=0 \
    rdwmin=0 rsw=0 rswmin=0 prwb=0 \
    prwg=0 wr=1 voff=-0.11934831869 lvoff=5.296050099455504E-9 \
    voffl=0 minv=0 nfactor=0.723459400166666 lnfactor=3.583940752490084E-7 \
    eta0=0.067637351756667 leta0=1.529144370447834E-9 etab=-0.077077273825 letab=9.70788263825875E-9 \
    dsub=0.58180516425 ldsub=-4.053136043728748E-8 cit=5E-6 cdsc=3.8556E-37 \
    cdscb=-1.1484E-4 cdscd=4.7984E-6 pclm=0.086824416666667 lpclm=9.59179572083335E-9 \
    pdiblc1=3.583688213883334 lpdiblc1=-4.029261769551058E-7 pdiblc2=0.064735802833333 lpdiblc2=-7.957785851858334E-9 \
    pdiblcb=0 drout=3.4946 pscbe1=4.5E8 pscbe2=1E-8 \
    pvag=0 delta=0.01 fprout=0 pdits=1.4427E-15 \
    pditsl=0 pditsd=0 lambda=0 vtl=0 \
    lc=0 xn=0 alpha0=1.687407635666667E-3 lalpha0=-1.627859334572167E-10 \
    alpha1=0 beta0=31.24083182666667 lbeta0=-3.496153888186668E-7 aigbacc=1 \
    bigbacc=0 cigbacc=0 nigbacc=1 aigbinv=0.35 \
    bigbinv=0.03 cigbinv=6E-3 eigbinv=1.1 nigbinv=3 \
    aigc=0.43 bigc=0.054 cigc=0.075 aigsd=0.43 \
    bigsd=0.054 cigsd=0.075 dlcig=0 nigc=1 \
    poxedge=1 pigcd=1 ntox=1 toxref=4.148E-9 \
    agidl=0 bgidl=2.3E9 cgidl=0.5 egidl=0.8 \
    noia=9E41 noib=1E27 noic=8E11 em=4.1E7 \
    af=1 ef=1.2 kf=0 lintnoi=-3E-7 \
    tnoia=2.5E7 tnoib=9.9E6 ntnoi=1 rnoia=0.912 \
    rnoib=0.26 xpart=0 cgso=2.392894381e-10 cgdo=2.392894381e-10 \
    cgbo=1e-14 ckappas=0.6 cf=1E-14 clc=1E-7 \
    cle=0.6 dlc=1.21071E-8 dwc=2.6E-8 vfbcv=-1 \
    noff=3.8661 voffcv=-0.16994 acde=0.38008 moin=23.81 \
    cgsl=2.310725e-11 cgdl=2.310725e-11 ijthsrev=0.1 ijthsfwd=0.1 \
    xjbvs=1 bvs=11.9 jss=2.75E-3 jsws=6E-10 \
    cjs=0.00121 mjs=0.42197 mjsws=1E-3 cjsws=3.230311424e-11 \
    cjswgs=1.795291232e-10 mjswgs=0.8 pbs=0.7477 pbsws=0.1 \
    pbswgs=0.79644 xrcrg1=12 xrcrg2=1 rbpb=50 \
    rbpd=50 rbps=50 rbdb=50 rbsb=50 \
    gbmin=1E-12 tnom=30 ute=-2.841387833333333 lute=1.462012276083332E-7 \
    kt1=-0.295119316666667 lkt1=-2.874265065833337E-9 kt1l=0 kt2=0.02122778 \
    lkt2=-5.743292291000001E-9 ua1=-2.42902207E-9 lua1=3.816539507165E-16 ub1=2.4443796E-18 \
    lub1=-4.0006627012E-25 uc1=5.2148775E-12 luc1=-5.195283211249999E-19 at=6.394335E4 \
    lat=2.4945216175E-3 prt=0 njs=1.2928 xtis=2 \
    tpb=1.2287E-3 tpbsw=0 tpbswg=0 tcj=7.92E-4 \
    tcjsw=1E-5 tcjswg=0 tvoff=0 tvfbsdoff=0 \
    saref=1.1E-6 sbref=1.1E-6 wlod=0 ku0=-2.7E-8 \
    kvsat=0.2 kvth0=7.9E-9 tku0=0 llodku0=0 \
    wlodku0=1 llodvth=0 wlodvth=1 lku0=0 \
    wku0=0 pku0=0 lkvth0=0 wkvth0=3E-7 \
    pkvth0=0 stk2=0 lodk2=1 steta0=0 \
    lodeta0=1 rsh=491.61731843575416

// l=0.15 w=53.7 nf=31 -> bin nlowvt_model.8  rsh=494.9358 delvto=0 (folded into vth0)
model nlowvt_model__w53p7nf31 bsim4 \
    type=n version=4.50 binunit=2 mobmod=0 \
    capmod=2 rdsmod=0 igcmod=0 igbmod=0 \
    rbodymod=1 trnqsmod=0 acnqsmod=0 fnoimod=1 \
    tnoimod=1 diomod=1 tempmod=0 permod=1 \
    geomod=0 rgatemod=0 epsrox=3.9 toxe=4.148E-9 \
    toxm=4.148E-9 dtox=0 xj=1.5E-7 ndep=1.7E17 \
    ngate=9.999999999999999E22 nsd=1E20 rshg=0.1 phin=0 \
    wint=2.6e-08 wl=0 wln=1 ww=0 \
    wwn=1 wwl=0 lint=1.2025e-08 ll=0 \
    lln=1 lw=0 lwn=1 lwl=0 \
    llc=0 lwc=0 lwlc=0 wlc=0 \
    wwc=0 wwlc=0 dwg=-1.33E-8 dwb=-1.08E-8 \
    xl=0 xw=0 dmcg=0 dmdg=0 \
    dmcgt=0 xgw=0 xgl=0 ngcon=1 \
    vth0=0.249959346666667 lvth0=-1.985141612666671E-9 vfb=0 k1=1.011211866666667 \
    lk1=-4.876429660666666E-8 k2=-0.21737859252 lk2=1.7355223637994E-8 k3=1.65 \
    k3b=1.6 w0=1E-7 lpe0=2.3802E-7 lpeb=-4.9152E-8 \
    vbm=-3 dvtp0=0 dvtp1=0 dvt0=0.07665 \
    dvt1=0.1252 dvt2=-0.05637 dvt0w=0 dvt1w=5.3E6 \
    dvt2w=-0.032 vfbsdoff=0 u0=0.01421071555 lu0=2.166698264775001E-10 \
    ua=-3.496851672833332E-9 lua=1.729222681883582E-16 ub=4.57941585E-18 lub=-2.719028563075E-25 \
    uc=1.863698448333334E-10 luc=-2.261771620175834E-17 ud=0 up=0 \
    lp=1 eu=1.67 vsat=1.819855189500001E5 lvsat=-1.786254255252507E-3 \
    a0=0 ags=1.005218833333333 lags=3.096873294166675E-8 b0=0 \
    b1=0 keta=0.1569286063 lketa=-4.276737497598501E-8 a1=0 \
    a2=0.38689047 rdsw=103.65 rdswmin=0 rdw=0 \
    rdwmin=0 rsw=0 rswmin=0 prwb=0 \
    prwg=0 wr=1 voff=-0.11934831869 lvoff=5.296050099455504E-9 \
    voffl=0 minv=0 nfactor=0.723459400166666 lnfactor=3.583940752490084E-7 \
    eta0=0.067637351756667 leta0=1.529144370447834E-9 etab=-0.077077273825 letab=9.70788263825875E-9 \
    dsub=0.58180516425 ldsub=-4.053136043728748E-8 cit=5E-6 cdsc=3.8556E-37 \
    cdscb=-1.1484E-4 cdscd=4.7984E-6 pclm=0.086824416666667 lpclm=9.59179572083335E-9 \
    pdiblc1=3.583688213883334 lpdiblc1=-4.029261769551058E-7 pdiblc2=0.064735802833333 lpdiblc2=-7.957785851858334E-9 \
    pdiblcb=0 drout=3.4946 pscbe1=4.5E8 pscbe2=1E-8 \
    pvag=0 delta=0.01 fprout=0 pdits=1.4427E-15 \
    pditsl=0 pditsd=0 lambda=0 vtl=0 \
    lc=0 xn=0 alpha0=1.687407635666667E-3 lalpha0=-1.627859334572167E-10 \
    alpha1=0 beta0=31.24083182666667 lbeta0=-3.496153888186668E-7 aigbacc=1 \
    bigbacc=0 cigbacc=0 nigbacc=1 aigbinv=0.35 \
    bigbinv=0.03 cigbinv=6E-3 eigbinv=1.1 nigbinv=3 \
    aigc=0.43 bigc=0.054 cigc=0.075 aigsd=0.43 \
    bigsd=0.054 cigsd=0.075 dlcig=0 nigc=1 \
    poxedge=1 pigcd=1 ntox=1 toxref=4.148E-9 \
    agidl=0 bgidl=2.3E9 cgidl=0.5 egidl=0.8 \
    noia=9E41 noib=1E27 noic=8E11 em=4.1E7 \
    af=1 ef=1.2 kf=0 lintnoi=-3E-7 \
    tnoia=2.5E7 tnoib=9.9E6 ntnoi=1 rnoia=0.912 \
    rnoib=0.26 xpart=0 cgso=2.392894381e-10 cgdo=2.392894381e-10 \
    cgbo=1e-14 ckappas=0.6 cf=1E-14 clc=1E-7 \
    cle=0.6 dlc=1.21071E-8 dwc=2.6E-8 vfbcv=-1 \
    noff=3.8661 voffcv=-0.16994 acde=0.38008 moin=23.81 \
    cgsl=2.310725e-11 cgdl=2.310725e-11 ijthsrev=0.1 ijthsfwd=0.1 \
    xjbvs=1 bvs=11.9 jss=2.75E-3 jsws=6E-10 \
    cjs=0.00121 mjs=0.42197 mjsws=1E-3 cjsws=3.230311424e-11 \
    cjswgs=1.795291232e-10 mjswgs=0.8 pbs=0.7477 pbsws=0.1 \
    pbswgs=0.79644 xrcrg1=12 xrcrg2=1 rbpb=50 \
    rbpd=50 rbps=50 rbdb=50 rbsb=50 \
    gbmin=1E-12 tnom=30 ute=-2.841387833333333 lute=1.462012276083332E-7 \
    kt1=-0.295119316666667 lkt1=-2.874265065833337E-9 kt1l=0 kt2=0.02122778 \
    lkt2=-5.743292291000001E-9 ua1=-2.42902207E-9 lua1=3.816539507165E-16 ub1=2.4443796E-18 \
    lub1=-4.0006627012E-25 uc1=5.2148775E-12 luc1=-5.195283211249999E-19 at=6.394335E4 \
    lat=2.4945216175E-3 prt=0 njs=1.2928 xtis=2 \
    tpb=1.2287E-3 tpbsw=0 tpbswg=0 tcj=7.92E-4 \
    tcjsw=1E-5 tcjswg=0 tvoff=0 tvfbsdoff=0 \
    saref=1.1E-6 sbref=1.1E-6 wlod=0 ku0=-2.7E-8 \
    kvsat=0.2 kvth0=7.9E-9 tku0=0 llodku0=0 \
    wlodku0=1 llodvth=0 wlodvth=1 lku0=0 \
    wku0=0 pku0=0 lkvth0=0 wkvth0=3E-7 \
    pkvth0=0 stk2=0 lodk2=1 steta0=0 \
    lodeta0=1 rsh=494.93575418994413

// l=0.15 w=53.7 nf=33 -> bin nlowvt_model.8  rsh=498.2542 delvto=0 (folded into vth0)
model nlowvt_model__w53p7nf33 bsim4 \
    type=n version=4.50 binunit=2 mobmod=0 \
    capmod=2 rdsmod=0 igcmod=0 igbmod=0 \
    rbodymod=1 trnqsmod=0 acnqsmod=0 fnoimod=1 \
    tnoimod=1 diomod=1 tempmod=0 permod=1 \
    geomod=0 rgatemod=0 epsrox=3.9 toxe=4.148E-9 \
    toxm=4.148E-9 dtox=0 xj=1.5E-7 ndep=1.7E17 \
    ngate=9.999999999999999E22 nsd=1E20 rshg=0.1 phin=0 \
    wint=2.6e-08 wl=0 wln=1 ww=0 \
    wwn=1 wwl=0 lint=1.2025e-08 ll=0 \
    lln=1 lw=0 lwn=1 lwl=0 \
    llc=0 lwc=0 lwlc=0 wlc=0 \
    wwc=0 wwlc=0 dwg=-1.33E-8 dwb=-1.08E-8 \
    xl=0 xw=0 dmcg=0 dmdg=0 \
    dmcgt=0 xgw=0 xgl=0 ngcon=1 \
    vth0=0.249959346666667 lvth0=-1.985141612666671E-9 vfb=0 k1=1.011211866666667 \
    lk1=-4.876429660666666E-8 k2=-0.21737859252 lk2=1.7355223637994E-8 k3=1.65 \
    k3b=1.6 w0=1E-7 lpe0=2.3802E-7 lpeb=-4.9152E-8 \
    vbm=-3 dvtp0=0 dvtp1=0 dvt0=0.07665 \
    dvt1=0.1252 dvt2=-0.05637 dvt0w=0 dvt1w=5.3E6 \
    dvt2w=-0.032 vfbsdoff=0 u0=0.01421071555 lu0=2.166698264775001E-10 \
    ua=-3.496851672833332E-9 lua=1.729222681883582E-16 ub=4.57941585E-18 lub=-2.719028563075E-25 \
    uc=1.863698448333334E-10 luc=-2.261771620175834E-17 ud=0 up=0 \
    lp=1 eu=1.67 vsat=1.819855189500001E5 lvsat=-1.786254255252507E-3 \
    a0=0 ags=1.005218833333333 lags=3.096873294166675E-8 b0=0 \
    b1=0 keta=0.1569286063 lketa=-4.276737497598501E-8 a1=0 \
    a2=0.38689047 rdsw=103.65 rdswmin=0 rdw=0 \
    rdwmin=0 rsw=0 rswmin=0 prwb=0 \
    prwg=0 wr=1 voff=-0.11934831869 lvoff=5.296050099455504E-9 \
    voffl=0 minv=0 nfactor=0.723459400166666 lnfactor=3.583940752490084E-7 \
    eta0=0.067637351756667 leta0=1.529144370447834E-9 etab=-0.077077273825 letab=9.70788263825875E-9 \
    dsub=0.58180516425 ldsub=-4.053136043728748E-8 cit=5E-6 cdsc=3.8556E-37 \
    cdscb=-1.1484E-4 cdscd=4.7984E-6 pclm=0.086824416666667 lpclm=9.59179572083335E-9 \
    pdiblc1=3.583688213883334 lpdiblc1=-4.029261769551058E-7 pdiblc2=0.064735802833333 lpdiblc2=-7.957785851858334E-9 \
    pdiblcb=0 drout=3.4946 pscbe1=4.5E8 pscbe2=1E-8 \
    pvag=0 delta=0.01 fprout=0 pdits=1.4427E-15 \
    pditsl=0 pditsd=0 lambda=0 vtl=0 \
    lc=0 xn=0 alpha0=1.687407635666667E-3 lalpha0=-1.627859334572167E-10 \
    alpha1=0 beta0=31.24083182666667 lbeta0=-3.496153888186668E-7 aigbacc=1 \
    bigbacc=0 cigbacc=0 nigbacc=1 aigbinv=0.35 \
    bigbinv=0.03 cigbinv=6E-3 eigbinv=1.1 nigbinv=3 \
    aigc=0.43 bigc=0.054 cigc=0.075 aigsd=0.43 \
    bigsd=0.054 cigsd=0.075 dlcig=0 nigc=1 \
    poxedge=1 pigcd=1 ntox=1 toxref=4.148E-9 \
    agidl=0 bgidl=2.3E9 cgidl=0.5 egidl=0.8 \
    noia=9E41 noib=1E27 noic=8E11 em=4.1E7 \
    af=1 ef=1.2 kf=0 lintnoi=-3E-7 \
    tnoia=2.5E7 tnoib=9.9E6 ntnoi=1 rnoia=0.912 \
    rnoib=0.26 xpart=0 cgso=2.392894381e-10 cgdo=2.392894381e-10 \
    cgbo=1e-14 ckappas=0.6 cf=1E-14 clc=1E-7 \
    cle=0.6 dlc=1.21071E-8 dwc=2.6E-8 vfbcv=-1 \
    noff=3.8661 voffcv=-0.16994 acde=0.38008 moin=23.81 \
    cgsl=2.310725e-11 cgdl=2.310725e-11 ijthsrev=0.1 ijthsfwd=0.1 \
    xjbvs=1 bvs=11.9 jss=2.75E-3 jsws=6E-10 \
    cjs=0.00121 mjs=0.42197 mjsws=1E-3 cjsws=3.230311424e-11 \
    cjswgs=1.795291232e-10 mjswgs=0.8 pbs=0.7477 pbsws=0.1 \
    pbswgs=0.79644 xrcrg1=12 xrcrg2=1 rbpb=50 \
    rbpd=50 rbps=50 rbdb=50 rbsb=50 \
    gbmin=1E-12 tnom=30 ute=-2.841387833333333 lute=1.462012276083332E-7 \
    kt1=-0.295119316666667 lkt1=-2.874265065833337E-9 kt1l=0 kt2=0.02122778 \
    lkt2=-5.743292291000001E-9 ua1=-2.42902207E-9 lua1=3.816539507165E-16 ub1=2.4443796E-18 \
    lub1=-4.0006627012E-25 uc1=5.2148775E-12 luc1=-5.195283211249999E-19 at=6.394335E4 \
    lat=2.4945216175E-3 prt=0 njs=1.2928 xtis=2 \
    tpb=1.2287E-3 tpbsw=0 tpbswg=0 tcj=7.92E-4 \
    tcjsw=1E-5 tcjswg=0 tvoff=0 tvfbsdoff=0 \
    saref=1.1E-6 sbref=1.1E-6 wlod=0 ku0=-2.7E-8 \
    kvsat=0.2 kvth0=7.9E-9 tku0=0 llodku0=0 \
    wlodku0=1 llodvth=0 wlodvth=1 lku0=0 \
    wku0=0 pku0=0 lkvth0=0 wkvth0=3E-7 \
    pkvth0=0 stk2=0 lodk2=1 steta0=0 \
    lodeta0=1 rsh=498.25418994413405

// l=0.15 w=53.7 nf=35 -> bin nlowvt_model.8  rsh=501.5726 delvto=0 (folded into vth0)
model nlowvt_model__w53p7nf35 bsim4 \
    type=n version=4.50 binunit=2 mobmod=0 \
    capmod=2 rdsmod=0 igcmod=0 igbmod=0 \
    rbodymod=1 trnqsmod=0 acnqsmod=0 fnoimod=1 \
    tnoimod=1 diomod=1 tempmod=0 permod=1 \
    geomod=0 rgatemod=0 epsrox=3.9 toxe=4.148E-9 \
    toxm=4.148E-9 dtox=0 xj=1.5E-7 ndep=1.7E17 \
    ngate=9.999999999999999E22 nsd=1E20 rshg=0.1 phin=0 \
    wint=2.6e-08 wl=0 wln=1 ww=0 \
    wwn=1 wwl=0 lint=1.2025e-08 ll=0 \
    lln=1 lw=0 lwn=1 lwl=0 \
    llc=0 lwc=0 lwlc=0 wlc=0 \
    wwc=0 wwlc=0 dwg=-1.33E-8 dwb=-1.08E-8 \
    xl=0 xw=0 dmcg=0 dmdg=0 \
    dmcgt=0 xgw=0 xgl=0 ngcon=1 \
    vth0=0.249959346666667 lvth0=-1.985141612666671E-9 vfb=0 k1=1.011211866666667 \
    lk1=-4.876429660666666E-8 k2=-0.21737859252 lk2=1.7355223637994E-8 k3=1.65 \
    k3b=1.6 w0=1E-7 lpe0=2.3802E-7 lpeb=-4.9152E-8 \
    vbm=-3 dvtp0=0 dvtp1=0 dvt0=0.07665 \
    dvt1=0.1252 dvt2=-0.05637 dvt0w=0 dvt1w=5.3E6 \
    dvt2w=-0.032 vfbsdoff=0 u0=0.01421071555 lu0=2.166698264775001E-10 \
    ua=-3.496851672833332E-9 lua=1.729222681883582E-16 ub=4.57941585E-18 lub=-2.719028563075E-25 \
    uc=1.863698448333334E-10 luc=-2.261771620175834E-17 ud=0 up=0 \
    lp=1 eu=1.67 vsat=1.819855189500001E5 lvsat=-1.786254255252507E-3 \
    a0=0 ags=1.005218833333333 lags=3.096873294166675E-8 b0=0 \
    b1=0 keta=0.1569286063 lketa=-4.276737497598501E-8 a1=0 \
    a2=0.38689047 rdsw=103.65 rdswmin=0 rdw=0 \
    rdwmin=0 rsw=0 rswmin=0 prwb=0 \
    prwg=0 wr=1 voff=-0.11934831869 lvoff=5.296050099455504E-9 \
    voffl=0 minv=0 nfactor=0.723459400166666 lnfactor=3.583940752490084E-7 \
    eta0=0.067637351756667 leta0=1.529144370447834E-9 etab=-0.077077273825 letab=9.70788263825875E-9 \
    dsub=0.58180516425 ldsub=-4.053136043728748E-8 cit=5E-6 cdsc=3.8556E-37 \
    cdscb=-1.1484E-4 cdscd=4.7984E-6 pclm=0.086824416666667 lpclm=9.59179572083335E-9 \
    pdiblc1=3.583688213883334 lpdiblc1=-4.029261769551058E-7 pdiblc2=0.064735802833333 lpdiblc2=-7.957785851858334E-9 \
    pdiblcb=0 drout=3.4946 pscbe1=4.5E8 pscbe2=1E-8 \
    pvag=0 delta=0.01 fprout=0 pdits=1.4427E-15 \
    pditsl=0 pditsd=0 lambda=0 vtl=0 \
    lc=0 xn=0 alpha0=1.687407635666667E-3 lalpha0=-1.627859334572167E-10 \
    alpha1=0 beta0=31.24083182666667 lbeta0=-3.496153888186668E-7 aigbacc=1 \
    bigbacc=0 cigbacc=0 nigbacc=1 aigbinv=0.35 \
    bigbinv=0.03 cigbinv=6E-3 eigbinv=1.1 nigbinv=3 \
    aigc=0.43 bigc=0.054 cigc=0.075 aigsd=0.43 \
    bigsd=0.054 cigsd=0.075 dlcig=0 nigc=1 \
    poxedge=1 pigcd=1 ntox=1 toxref=4.148E-9 \
    agidl=0 bgidl=2.3E9 cgidl=0.5 egidl=0.8 \
    noia=9E41 noib=1E27 noic=8E11 em=4.1E7 \
    af=1 ef=1.2 kf=0 lintnoi=-3E-7 \
    tnoia=2.5E7 tnoib=9.9E6 ntnoi=1 rnoia=0.912 \
    rnoib=0.26 xpart=0 cgso=2.392894381e-10 cgdo=2.392894381e-10 \
    cgbo=1e-14 ckappas=0.6 cf=1E-14 clc=1E-7 \
    cle=0.6 dlc=1.21071E-8 dwc=2.6E-8 vfbcv=-1 \
    noff=3.8661 voffcv=-0.16994 acde=0.38008 moin=23.81 \
    cgsl=2.310725e-11 cgdl=2.310725e-11 ijthsrev=0.1 ijthsfwd=0.1 \
    xjbvs=1 bvs=11.9 jss=2.75E-3 jsws=6E-10 \
    cjs=0.00121 mjs=0.42197 mjsws=1E-3 cjsws=3.230311424e-11 \
    cjswgs=1.795291232e-10 mjswgs=0.8 pbs=0.7477 pbsws=0.1 \
    pbswgs=0.79644 xrcrg1=12 xrcrg2=1 rbpb=50 \
    rbpd=50 rbps=50 rbdb=50 rbsb=50 \
    gbmin=1E-12 tnom=30 ute=-2.841387833333333 lute=1.462012276083332E-7 \
    kt1=-0.295119316666667 lkt1=-2.874265065833337E-9 kt1l=0 kt2=0.02122778 \
    lkt2=-5.743292291000001E-9 ua1=-2.42902207E-9 lua1=3.816539507165E-16 ub1=2.4443796E-18 \
    lub1=-4.0006627012E-25 uc1=5.2148775E-12 luc1=-5.195283211249999E-19 at=6.394335E4 \
    lat=2.4945216175E-3 prt=0 njs=1.2928 xtis=2 \
    tpb=1.2287E-3 tpbsw=0 tpbswg=0 tcj=7.92E-4 \
    tcjsw=1E-5 tcjswg=0 tvoff=0 tvfbsdoff=0 \
    saref=1.1E-6 sbref=1.1E-6 wlod=0 ku0=-2.7E-8 \
    kvsat=0.2 kvth0=7.9E-9 tku0=0 llodku0=0 \
    wlodku0=1 llodvth=0 wlodvth=1 lku0=0 \
    wku0=0 pku0=0 lkvth0=0 wkvth0=3E-7 \
    pkvth0=0 stk2=0 lodk2=1 steta0=0 \
    lodeta0=1 rsh=501.57262569832403

// l=0.15 w=57.7 nf=27 -> bin nlowvt_model.8  rsh=485.1932 delvto=0 (folded into vth0)
model nlowvt_model__w57p7nf27 bsim4 \
    type=n version=4.50 binunit=2 mobmod=0 \
    capmod=2 rdsmod=0 igcmod=0 igbmod=0 \
    rbodymod=1 trnqsmod=0 acnqsmod=0 fnoimod=1 \
    tnoimod=1 diomod=1 tempmod=0 permod=1 \
    geomod=0 rgatemod=0 epsrox=3.9 toxe=4.148E-9 \
    toxm=4.148E-9 dtox=0 xj=1.5E-7 ndep=1.7E17 \
    ngate=9.999999999999999E22 nsd=1E20 rshg=0.1 phin=0 \
    wint=2.6e-08 wl=0 wln=1 ww=0 \
    wwn=1 wwl=0 lint=1.2025e-08 ll=0 \
    lln=1 lw=0 lwn=1 lwl=0 \
    llc=0 lwc=0 lwlc=0 wlc=0 \
    wwc=0 wwlc=0 dwg=-1.33E-8 dwb=-1.08E-8 \
    xl=0 xw=0 dmcg=0 dmdg=0 \
    dmcgt=0 xgw=0 xgl=0 ngcon=1 \
    vth0=0.249959346666667 lvth0=-1.985141612666671E-9 vfb=0 k1=1.011211866666667 \
    lk1=-4.876429660666666E-8 k2=-0.21737859252 lk2=1.7355223637994E-8 k3=1.65 \
    k3b=1.6 w0=1E-7 lpe0=2.3802E-7 lpeb=-4.9152E-8 \
    vbm=-3 dvtp0=0 dvtp1=0 dvt0=0.07665 \
    dvt1=0.1252 dvt2=-0.05637 dvt0w=0 dvt1w=5.3E6 \
    dvt2w=-0.032 vfbsdoff=0 u0=0.01421071555 lu0=2.166698264775001E-10 \
    ua=-3.496851672833332E-9 lua=1.729222681883582E-16 ub=4.57941585E-18 lub=-2.719028563075E-25 \
    uc=1.863698448333334E-10 luc=-2.261771620175834E-17 ud=0 up=0 \
    lp=1 eu=1.67 vsat=1.819855189500001E5 lvsat=-1.786254255252507E-3 \
    a0=0 ags=1.005218833333333 lags=3.096873294166675E-8 b0=0 \
    b1=0 keta=0.1569286063 lketa=-4.276737497598501E-8 a1=0 \
    a2=0.38689047 rdsw=103.65 rdswmin=0 rdw=0 \
    rdwmin=0 rsw=0 rswmin=0 prwb=0 \
    prwg=0 wr=1 voff=-0.11934831869 lvoff=5.296050099455504E-9 \
    voffl=0 minv=0 nfactor=0.723459400166666 lnfactor=3.583940752490084E-7 \
    eta0=0.067637351756667 leta0=1.529144370447834E-9 etab=-0.077077273825 letab=9.70788263825875E-9 \
    dsub=0.58180516425 ldsub=-4.053136043728748E-8 cit=5E-6 cdsc=3.8556E-37 \
    cdscb=-1.1484E-4 cdscd=4.7984E-6 pclm=0.086824416666667 lpclm=9.59179572083335E-9 \
    pdiblc1=3.583688213883334 lpdiblc1=-4.029261769551058E-7 pdiblc2=0.064735802833333 lpdiblc2=-7.957785851858334E-9 \
    pdiblcb=0 drout=3.4946 pscbe1=4.5E8 pscbe2=1E-8 \
    pvag=0 delta=0.01 fprout=0 pdits=1.4427E-15 \
    pditsl=0 pditsd=0 lambda=0 vtl=0 \
    lc=0 xn=0 alpha0=1.687407635666667E-3 lalpha0=-1.627859334572167E-10 \
    alpha1=0 beta0=31.24083182666667 lbeta0=-3.496153888186668E-7 aigbacc=1 \
    bigbacc=0 cigbacc=0 nigbacc=1 aigbinv=0.35 \
    bigbinv=0.03 cigbinv=6E-3 eigbinv=1.1 nigbinv=3 \
    aigc=0.43 bigc=0.054 cigc=0.075 aigsd=0.43 \
    bigsd=0.054 cigsd=0.075 dlcig=0 nigc=1 \
    poxedge=1 pigcd=1 ntox=1 toxref=4.148E-9 \
    agidl=0 bgidl=2.3E9 cgidl=0.5 egidl=0.8 \
    noia=9E41 noib=1E27 noic=8E11 em=4.1E7 \
    af=1 ef=1.2 kf=0 lintnoi=-3E-7 \
    tnoia=2.5E7 tnoib=9.9E6 ntnoi=1 rnoia=0.912 \
    rnoib=0.26 xpart=0 cgso=2.392894381e-10 cgdo=2.392894381e-10 \
    cgbo=1e-14 ckappas=0.6 cf=1E-14 clc=1E-7 \
    cle=0.6 dlc=1.21071E-8 dwc=2.6E-8 vfbcv=-1 \
    noff=3.8661 voffcv=-0.16994 acde=0.38008 moin=23.81 \
    cgsl=2.310725e-11 cgdl=2.310725e-11 ijthsrev=0.1 ijthsfwd=0.1 \
    xjbvs=1 bvs=11.9 jss=2.75E-3 jsws=6E-10 \
    cjs=0.00121 mjs=0.42197 mjsws=1E-3 cjsws=3.230311424e-11 \
    cjswgs=1.795291232e-10 mjswgs=0.8 pbs=0.7477 pbsws=0.1 \
    pbswgs=0.79644 xrcrg1=12 xrcrg2=1 rbpb=50 \
    rbpd=50 rbps=50 rbdb=50 rbsb=50 \
    gbmin=1E-12 tnom=30 ute=-2.841387833333333 lute=1.462012276083332E-7 \
    kt1=-0.295119316666667 lkt1=-2.874265065833337E-9 kt1l=0 kt2=0.02122778 \
    lkt2=-5.743292291000001E-9 ua1=-2.42902207E-9 lua1=3.816539507165E-16 ub1=2.4443796E-18 \
    lub1=-4.0006627012E-25 uc1=5.2148775E-12 luc1=-5.195283211249999E-19 at=6.394335E4 \
    lat=2.4945216175E-3 prt=0 njs=1.2928 xtis=2 \
    tpb=1.2287E-3 tpbsw=0 tpbswg=0 tcj=7.92E-4 \
    tcjsw=1E-5 tcjswg=0 tvoff=0 tvfbsdoff=0 \
    saref=1.1E-6 sbref=1.1E-6 wlod=0 ku0=-2.7E-8 \
    kvsat=0.2 kvth0=7.9E-9 tku0=0 llodku0=0 \
    wlodku0=1 llodvth=0 wlodvth=1 lku0=0 \
    wku0=0 pku0=0 lkvth0=0 wkvth0=3E-7 \
    pkvth0=0 stk2=0 lodk2=1 steta0=0 \
    lodeta0=1 rsh=485.1932409012132

// l=0.15 w=57.7 nf=29 -> bin nlowvt_model.8  rsh=488.2816 delvto=0 (folded into vth0)
model nlowvt_model__w57p7nf29 bsim4 \
    type=n version=4.50 binunit=2 mobmod=0 \
    capmod=2 rdsmod=0 igcmod=0 igbmod=0 \
    rbodymod=1 trnqsmod=0 acnqsmod=0 fnoimod=1 \
    tnoimod=1 diomod=1 tempmod=0 permod=1 \
    geomod=0 rgatemod=0 epsrox=3.9 toxe=4.148E-9 \
    toxm=4.148E-9 dtox=0 xj=1.5E-7 ndep=1.7E17 \
    ngate=9.999999999999999E22 nsd=1E20 rshg=0.1 phin=0 \
    wint=2.6e-08 wl=0 wln=1 ww=0 \
    wwn=1 wwl=0 lint=1.2025e-08 ll=0 \
    lln=1 lw=0 lwn=1 lwl=0 \
    llc=0 lwc=0 lwlc=0 wlc=0 \
    wwc=0 wwlc=0 dwg=-1.33E-8 dwb=-1.08E-8 \
    xl=0 xw=0 dmcg=0 dmdg=0 \
    dmcgt=0 xgw=0 xgl=0 ngcon=1 \
    vth0=0.249959346666667 lvth0=-1.985141612666671E-9 vfb=0 k1=1.011211866666667 \
    lk1=-4.876429660666666E-8 k2=-0.21737859252 lk2=1.7355223637994E-8 k3=1.65 \
    k3b=1.6 w0=1E-7 lpe0=2.3802E-7 lpeb=-4.9152E-8 \
    vbm=-3 dvtp0=0 dvtp1=0 dvt0=0.07665 \
    dvt1=0.1252 dvt2=-0.05637 dvt0w=0 dvt1w=5.3E6 \
    dvt2w=-0.032 vfbsdoff=0 u0=0.01421071555 lu0=2.166698264775001E-10 \
    ua=-3.496851672833332E-9 lua=1.729222681883582E-16 ub=4.57941585E-18 lub=-2.719028563075E-25 \
    uc=1.863698448333334E-10 luc=-2.261771620175834E-17 ud=0 up=0 \
    lp=1 eu=1.67 vsat=1.819855189500001E5 lvsat=-1.786254255252507E-3 \
    a0=0 ags=1.005218833333333 lags=3.096873294166675E-8 b0=0 \
    b1=0 keta=0.1569286063 lketa=-4.276737497598501E-8 a1=0 \
    a2=0.38689047 rdsw=103.65 rdswmin=0 rdw=0 \
    rdwmin=0 rsw=0 rswmin=0 prwb=0 \
    prwg=0 wr=1 voff=-0.11934831869 lvoff=5.296050099455504E-9 \
    voffl=0 minv=0 nfactor=0.723459400166666 lnfactor=3.583940752490084E-7 \
    eta0=0.067637351756667 leta0=1.529144370447834E-9 etab=-0.077077273825 letab=9.70788263825875E-9 \
    dsub=0.58180516425 ldsub=-4.053136043728748E-8 cit=5E-6 cdsc=3.8556E-37 \
    cdscb=-1.1484E-4 cdscd=4.7984E-6 pclm=0.086824416666667 lpclm=9.59179572083335E-9 \
    pdiblc1=3.583688213883334 lpdiblc1=-4.029261769551058E-7 pdiblc2=0.064735802833333 lpdiblc2=-7.957785851858334E-9 \
    pdiblcb=0 drout=3.4946 pscbe1=4.5E8 pscbe2=1E-8 \
    pvag=0 delta=0.01 fprout=0 pdits=1.4427E-15 \
    pditsl=0 pditsd=0 lambda=0 vtl=0 \
    lc=0 xn=0 alpha0=1.687407635666667E-3 lalpha0=-1.627859334572167E-10 \
    alpha1=0 beta0=31.24083182666667 lbeta0=-3.496153888186668E-7 aigbacc=1 \
    bigbacc=0 cigbacc=0 nigbacc=1 aigbinv=0.35 \
    bigbinv=0.03 cigbinv=6E-3 eigbinv=1.1 nigbinv=3 \
    aigc=0.43 bigc=0.054 cigc=0.075 aigsd=0.43 \
    bigsd=0.054 cigsd=0.075 dlcig=0 nigc=1 \
    poxedge=1 pigcd=1 ntox=1 toxref=4.148E-9 \
    agidl=0 bgidl=2.3E9 cgidl=0.5 egidl=0.8 \
    noia=9E41 noib=1E27 noic=8E11 em=4.1E7 \
    af=1 ef=1.2 kf=0 lintnoi=-3E-7 \
    tnoia=2.5E7 tnoib=9.9E6 ntnoi=1 rnoia=0.912 \
    rnoib=0.26 xpart=0 cgso=2.392894381e-10 cgdo=2.392894381e-10 \
    cgbo=1e-14 ckappas=0.6 cf=1E-14 clc=1E-7 \
    cle=0.6 dlc=1.21071E-8 dwc=2.6E-8 vfbcv=-1 \
    noff=3.8661 voffcv=-0.16994 acde=0.38008 moin=23.81 \
    cgsl=2.310725e-11 cgdl=2.310725e-11 ijthsrev=0.1 ijthsfwd=0.1 \
    xjbvs=1 bvs=11.9 jss=2.75E-3 jsws=6E-10 \
    cjs=0.00121 mjs=0.42197 mjsws=1E-3 cjsws=3.230311424e-11 \
    cjswgs=1.795291232e-10 mjswgs=0.8 pbs=0.7477 pbsws=0.1 \
    pbswgs=0.79644 xrcrg1=12 xrcrg2=1 rbpb=50 \
    rbpd=50 rbps=50 rbdb=50 rbsb=50 \
    gbmin=1E-12 tnom=30 ute=-2.841387833333333 lute=1.462012276083332E-7 \
    kt1=-0.295119316666667 lkt1=-2.874265065833337E-9 kt1l=0 kt2=0.02122778 \
    lkt2=-5.743292291000001E-9 ua1=-2.42902207E-9 lua1=3.816539507165E-16 ub1=2.4443796E-18 \
    lub1=-4.0006627012E-25 uc1=5.2148775E-12 luc1=-5.195283211249999E-19 at=6.394335E4 \
    lat=2.4945216175E-3 prt=0 njs=1.2928 xtis=2 \
    tpb=1.2287E-3 tpbsw=0 tpbswg=0 tcj=7.92E-4 \
    tcjsw=1E-5 tcjswg=0 tvoff=0 tvfbsdoff=0 \
    saref=1.1E-6 sbref=1.1E-6 wlod=0 ku0=-2.7E-8 \
    kvsat=0.2 kvth0=7.9E-9 tku0=0 llodku0=0 \
    wlodku0=1 llodvth=0 wlodvth=1 lku0=0 \
    wku0=0 pku0=0 lkvth0=0 wkvth0=3E-7 \
    pkvth0=0 stk2=0 lodk2=1 steta0=0 \
    lodeta0=1 rsh=488.28162911611787

// l=0.15 w=57.7 nf=31 -> bin nlowvt_model.8  rsh=491.3700 delvto=0 (folded into vth0)
model nlowvt_model__w57p7nf31 bsim4 \
    type=n version=4.50 binunit=2 mobmod=0 \
    capmod=2 rdsmod=0 igcmod=0 igbmod=0 \
    rbodymod=1 trnqsmod=0 acnqsmod=0 fnoimod=1 \
    tnoimod=1 diomod=1 tempmod=0 permod=1 \
    geomod=0 rgatemod=0 epsrox=3.9 toxe=4.148E-9 \
    toxm=4.148E-9 dtox=0 xj=1.5E-7 ndep=1.7E17 \
    ngate=9.999999999999999E22 nsd=1E20 rshg=0.1 phin=0 \
    wint=2.6e-08 wl=0 wln=1 ww=0 \
    wwn=1 wwl=0 lint=1.2025e-08 ll=0 \
    lln=1 lw=0 lwn=1 lwl=0 \
    llc=0 lwc=0 lwlc=0 wlc=0 \
    wwc=0 wwlc=0 dwg=-1.33E-8 dwb=-1.08E-8 \
    xl=0 xw=0 dmcg=0 dmdg=0 \
    dmcgt=0 xgw=0 xgl=0 ngcon=1 \
    vth0=0.249959346666667 lvth0=-1.985141612666671E-9 vfb=0 k1=1.011211866666667 \
    lk1=-4.876429660666666E-8 k2=-0.21737859252 lk2=1.7355223637994E-8 k3=1.65 \
    k3b=1.6 w0=1E-7 lpe0=2.3802E-7 lpeb=-4.9152E-8 \
    vbm=-3 dvtp0=0 dvtp1=0 dvt0=0.07665 \
    dvt1=0.1252 dvt2=-0.05637 dvt0w=0 dvt1w=5.3E6 \
    dvt2w=-0.032 vfbsdoff=0 u0=0.01421071555 lu0=2.166698264775001E-10 \
    ua=-3.496851672833332E-9 lua=1.729222681883582E-16 ub=4.57941585E-18 lub=-2.719028563075E-25 \
    uc=1.863698448333334E-10 luc=-2.261771620175834E-17 ud=0 up=0 \
    lp=1 eu=1.67 vsat=1.819855189500001E5 lvsat=-1.786254255252507E-3 \
    a0=0 ags=1.005218833333333 lags=3.096873294166675E-8 b0=0 \
    b1=0 keta=0.1569286063 lketa=-4.276737497598501E-8 a1=0 \
    a2=0.38689047 rdsw=103.65 rdswmin=0 rdw=0 \
    rdwmin=0 rsw=0 rswmin=0 prwb=0 \
    prwg=0 wr=1 voff=-0.11934831869 lvoff=5.296050099455504E-9 \
    voffl=0 minv=0 nfactor=0.723459400166666 lnfactor=3.583940752490084E-7 \
    eta0=0.067637351756667 leta0=1.529144370447834E-9 etab=-0.077077273825 letab=9.70788263825875E-9 \
    dsub=0.58180516425 ldsub=-4.053136043728748E-8 cit=5E-6 cdsc=3.8556E-37 \
    cdscb=-1.1484E-4 cdscd=4.7984E-6 pclm=0.086824416666667 lpclm=9.59179572083335E-9 \
    pdiblc1=3.583688213883334 lpdiblc1=-4.029261769551058E-7 pdiblc2=0.064735802833333 lpdiblc2=-7.957785851858334E-9 \
    pdiblcb=0 drout=3.4946 pscbe1=4.5E8 pscbe2=1E-8 \
    pvag=0 delta=0.01 fprout=0 pdits=1.4427E-15 \
    pditsl=0 pditsd=0 lambda=0 vtl=0 \
    lc=0 xn=0 alpha0=1.687407635666667E-3 lalpha0=-1.627859334572167E-10 \
    alpha1=0 beta0=31.24083182666667 lbeta0=-3.496153888186668E-7 aigbacc=1 \
    bigbacc=0 cigbacc=0 nigbacc=1 aigbinv=0.35 \
    bigbinv=0.03 cigbinv=6E-3 eigbinv=1.1 nigbinv=3 \
    aigc=0.43 bigc=0.054 cigc=0.075 aigsd=0.43 \
    bigsd=0.054 cigsd=0.075 dlcig=0 nigc=1 \
    poxedge=1 pigcd=1 ntox=1 toxref=4.148E-9 \
    agidl=0 bgidl=2.3E9 cgidl=0.5 egidl=0.8 \
    noia=9E41 noib=1E27 noic=8E11 em=4.1E7 \
    af=1 ef=1.2 kf=0 lintnoi=-3E-7 \
    tnoia=2.5E7 tnoib=9.9E6 ntnoi=1 rnoia=0.912 \
    rnoib=0.26 xpart=0 cgso=2.392894381e-10 cgdo=2.392894381e-10 \
    cgbo=1e-14 ckappas=0.6 cf=1E-14 clc=1E-7 \
    cle=0.6 dlc=1.21071E-8 dwc=2.6E-8 vfbcv=-1 \
    noff=3.8661 voffcv=-0.16994 acde=0.38008 moin=23.81 \
    cgsl=2.310725e-11 cgdl=2.310725e-11 ijthsrev=0.1 ijthsfwd=0.1 \
    xjbvs=1 bvs=11.9 jss=2.75E-3 jsws=6E-10 \
    cjs=0.00121 mjs=0.42197 mjsws=1E-3 cjsws=3.230311424e-11 \
    cjswgs=1.795291232e-10 mjswgs=0.8 pbs=0.7477 pbsws=0.1 \
    pbswgs=0.79644 xrcrg1=12 xrcrg2=1 rbpb=50 \
    rbpd=50 rbps=50 rbdb=50 rbsb=50 \
    gbmin=1E-12 tnom=30 ute=-2.841387833333333 lute=1.462012276083332E-7 \
    kt1=-0.295119316666667 lkt1=-2.874265065833337E-9 kt1l=0 kt2=0.02122778 \
    lkt2=-5.743292291000001E-9 ua1=-2.42902207E-9 lua1=3.816539507165E-16 ub1=2.4443796E-18 \
    lub1=-4.0006627012E-25 uc1=5.2148775E-12 luc1=-5.195283211249999E-19 at=6.394335E4 \
    lat=2.4945216175E-3 prt=0 njs=1.2928 xtis=2 \
    tpb=1.2287E-3 tpbsw=0 tpbswg=0 tcj=7.92E-4 \
    tcjsw=1E-5 tcjswg=0 tvoff=0 tvfbsdoff=0 \
    saref=1.1E-6 sbref=1.1E-6 wlod=0 ku0=-2.7E-8 \
    kvsat=0.2 kvth0=7.9E-9 tku0=0 llodku0=0 \
    wlodku0=1 llodvth=0 wlodvth=1 lku0=0 \
    wku0=0 pku0=0 lkvth0=0 wkvth0=3E-7 \
    pkvth0=0 stk2=0 lodk2=1 steta0=0 \
    lodeta0=1 rsh=491.3700173310225

// l=0.15 w=57.7 nf=33 -> bin nlowvt_model.8  rsh=494.4584 delvto=0 (folded into vth0)
model nlowvt_model__w57p7nf33 bsim4 \
    type=n version=4.50 binunit=2 mobmod=0 \
    capmod=2 rdsmod=0 igcmod=0 igbmod=0 \
    rbodymod=1 trnqsmod=0 acnqsmod=0 fnoimod=1 \
    tnoimod=1 diomod=1 tempmod=0 permod=1 \
    geomod=0 rgatemod=0 epsrox=3.9 toxe=4.148E-9 \
    toxm=4.148E-9 dtox=0 xj=1.5E-7 ndep=1.7E17 \
    ngate=9.999999999999999E22 nsd=1E20 rshg=0.1 phin=0 \
    wint=2.6e-08 wl=0 wln=1 ww=0 \
    wwn=1 wwl=0 lint=1.2025e-08 ll=0 \
    lln=1 lw=0 lwn=1 lwl=0 \
    llc=0 lwc=0 lwlc=0 wlc=0 \
    wwc=0 wwlc=0 dwg=-1.33E-8 dwb=-1.08E-8 \
    xl=0 xw=0 dmcg=0 dmdg=0 \
    dmcgt=0 xgw=0 xgl=0 ngcon=1 \
    vth0=0.249959346666667 lvth0=-1.985141612666671E-9 vfb=0 k1=1.011211866666667 \
    lk1=-4.876429660666666E-8 k2=-0.21737859252 lk2=1.7355223637994E-8 k3=1.65 \
    k3b=1.6 w0=1E-7 lpe0=2.3802E-7 lpeb=-4.9152E-8 \
    vbm=-3 dvtp0=0 dvtp1=0 dvt0=0.07665 \
    dvt1=0.1252 dvt2=-0.05637 dvt0w=0 dvt1w=5.3E6 \
    dvt2w=-0.032 vfbsdoff=0 u0=0.01421071555 lu0=2.166698264775001E-10 \
    ua=-3.496851672833332E-9 lua=1.729222681883582E-16 ub=4.57941585E-18 lub=-2.719028563075E-25 \
    uc=1.863698448333334E-10 luc=-2.261771620175834E-17 ud=0 up=0 \
    lp=1 eu=1.67 vsat=1.819855189500001E5 lvsat=-1.786254255252507E-3 \
    a0=0 ags=1.005218833333333 lags=3.096873294166675E-8 b0=0 \
    b1=0 keta=0.1569286063 lketa=-4.276737497598501E-8 a1=0 \
    a2=0.38689047 rdsw=103.65 rdswmin=0 rdw=0 \
    rdwmin=0 rsw=0 rswmin=0 prwb=0 \
    prwg=0 wr=1 voff=-0.11934831869 lvoff=5.296050099455504E-9 \
    voffl=0 minv=0 nfactor=0.723459400166666 lnfactor=3.583940752490084E-7 \
    eta0=0.067637351756667 leta0=1.529144370447834E-9 etab=-0.077077273825 letab=9.70788263825875E-9 \
    dsub=0.58180516425 ldsub=-4.053136043728748E-8 cit=5E-6 cdsc=3.8556E-37 \
    cdscb=-1.1484E-4 cdscd=4.7984E-6 pclm=0.086824416666667 lpclm=9.59179572083335E-9 \
    pdiblc1=3.583688213883334 lpdiblc1=-4.029261769551058E-7 pdiblc2=0.064735802833333 lpdiblc2=-7.957785851858334E-9 \
    pdiblcb=0 drout=3.4946 pscbe1=4.5E8 pscbe2=1E-8 \
    pvag=0 delta=0.01 fprout=0 pdits=1.4427E-15 \
    pditsl=0 pditsd=0 lambda=0 vtl=0 \
    lc=0 xn=0 alpha0=1.687407635666667E-3 lalpha0=-1.627859334572167E-10 \
    alpha1=0 beta0=31.24083182666667 lbeta0=-3.496153888186668E-7 aigbacc=1 \
    bigbacc=0 cigbacc=0 nigbacc=1 aigbinv=0.35 \
    bigbinv=0.03 cigbinv=6E-3 eigbinv=1.1 nigbinv=3 \
    aigc=0.43 bigc=0.054 cigc=0.075 aigsd=0.43 \
    bigsd=0.054 cigsd=0.075 dlcig=0 nigc=1 \
    poxedge=1 pigcd=1 ntox=1 toxref=4.148E-9 \
    agidl=0 bgidl=2.3E9 cgidl=0.5 egidl=0.8 \
    noia=9E41 noib=1E27 noic=8E11 em=4.1E7 \
    af=1 ef=1.2 kf=0 lintnoi=-3E-7 \
    tnoia=2.5E7 tnoib=9.9E6 ntnoi=1 rnoia=0.912 \
    rnoib=0.26 xpart=0 cgso=2.392894381e-10 cgdo=2.392894381e-10 \
    cgbo=1e-14 ckappas=0.6 cf=1E-14 clc=1E-7 \
    cle=0.6 dlc=1.21071E-8 dwc=2.6E-8 vfbcv=-1 \
    noff=3.8661 voffcv=-0.16994 acde=0.38008 moin=23.81 \
    cgsl=2.310725e-11 cgdl=2.310725e-11 ijthsrev=0.1 ijthsfwd=0.1 \
    xjbvs=1 bvs=11.9 jss=2.75E-3 jsws=6E-10 \
    cjs=0.00121 mjs=0.42197 mjsws=1E-3 cjsws=3.230311424e-11 \
    cjswgs=1.795291232e-10 mjswgs=0.8 pbs=0.7477 pbsws=0.1 \
    pbswgs=0.79644 xrcrg1=12 xrcrg2=1 rbpb=50 \
    rbpd=50 rbps=50 rbdb=50 rbsb=50 \
    gbmin=1E-12 tnom=30 ute=-2.841387833333333 lute=1.462012276083332E-7 \
    kt1=-0.295119316666667 lkt1=-2.874265065833337E-9 kt1l=0 kt2=0.02122778 \
    lkt2=-5.743292291000001E-9 ua1=-2.42902207E-9 lua1=3.816539507165E-16 ub1=2.4443796E-18 \
    lub1=-4.0006627012E-25 uc1=5.2148775E-12 luc1=-5.195283211249999E-19 at=6.394335E4 \
    lat=2.4945216175E-3 prt=0 njs=1.2928 xtis=2 \
    tpb=1.2287E-3 tpbsw=0 tpbswg=0 tcj=7.92E-4 \
    tcjsw=1E-5 tcjswg=0 tvoff=0 tvfbsdoff=0 \
    saref=1.1E-6 sbref=1.1E-6 wlod=0 ku0=-2.7E-8 \
    kvsat=0.2 kvth0=7.9E-9 tku0=0 llodku0=0 \
    wlodku0=1 llodvth=0 wlodvth=1 lku0=0 \
    wku0=0 pku0=0 lkvth0=0 wkvth0=3E-7 \
    pkvth0=0 stk2=0 lodk2=1 steta0=0 \
    lodeta0=1 rsh=494.4584055459272

// l=0.15 w=57.7 nf=35 -> bin nlowvt_model.8  rsh=497.5468 delvto=0 (folded into vth0)
model nlowvt_model__w57p7nf35 bsim4 \
    type=n version=4.50 binunit=2 mobmod=0 \
    capmod=2 rdsmod=0 igcmod=0 igbmod=0 \
    rbodymod=1 trnqsmod=0 acnqsmod=0 fnoimod=1 \
    tnoimod=1 diomod=1 tempmod=0 permod=1 \
    geomod=0 rgatemod=0 epsrox=3.9 toxe=4.148E-9 \
    toxm=4.148E-9 dtox=0 xj=1.5E-7 ndep=1.7E17 \
    ngate=9.999999999999999E22 nsd=1E20 rshg=0.1 phin=0 \
    wint=2.6e-08 wl=0 wln=1 ww=0 \
    wwn=1 wwl=0 lint=1.2025e-08 ll=0 \
    lln=1 lw=0 lwn=1 lwl=0 \
    llc=0 lwc=0 lwlc=0 wlc=0 \
    wwc=0 wwlc=0 dwg=-1.33E-8 dwb=-1.08E-8 \
    xl=0 xw=0 dmcg=0 dmdg=0 \
    dmcgt=0 xgw=0 xgl=0 ngcon=1 \
    vth0=0.249959346666667 lvth0=-1.985141612666671E-9 vfb=0 k1=1.011211866666667 \
    lk1=-4.876429660666666E-8 k2=-0.21737859252 lk2=1.7355223637994E-8 k3=1.65 \
    k3b=1.6 w0=1E-7 lpe0=2.3802E-7 lpeb=-4.9152E-8 \
    vbm=-3 dvtp0=0 dvtp1=0 dvt0=0.07665 \
    dvt1=0.1252 dvt2=-0.05637 dvt0w=0 dvt1w=5.3E6 \
    dvt2w=-0.032 vfbsdoff=0 u0=0.01421071555 lu0=2.166698264775001E-10 \
    ua=-3.496851672833332E-9 lua=1.729222681883582E-16 ub=4.57941585E-18 lub=-2.719028563075E-25 \
    uc=1.863698448333334E-10 luc=-2.261771620175834E-17 ud=0 up=0 \
    lp=1 eu=1.67 vsat=1.819855189500001E5 lvsat=-1.786254255252507E-3 \
    a0=0 ags=1.005218833333333 lags=3.096873294166675E-8 b0=0 \
    b1=0 keta=0.1569286063 lketa=-4.276737497598501E-8 a1=0 \
    a2=0.38689047 rdsw=103.65 rdswmin=0 rdw=0 \
    rdwmin=0 rsw=0 rswmin=0 prwb=0 \
    prwg=0 wr=1 voff=-0.11934831869 lvoff=5.296050099455504E-9 \
    voffl=0 minv=0 nfactor=0.723459400166666 lnfactor=3.583940752490084E-7 \
    eta0=0.067637351756667 leta0=1.529144370447834E-9 etab=-0.077077273825 letab=9.70788263825875E-9 \
    dsub=0.58180516425 ldsub=-4.053136043728748E-8 cit=5E-6 cdsc=3.8556E-37 \
    cdscb=-1.1484E-4 cdscd=4.7984E-6 pclm=0.086824416666667 lpclm=9.59179572083335E-9 \
    pdiblc1=3.583688213883334 lpdiblc1=-4.029261769551058E-7 pdiblc2=0.064735802833333 lpdiblc2=-7.957785851858334E-9 \
    pdiblcb=0 drout=3.4946 pscbe1=4.5E8 pscbe2=1E-8 \
    pvag=0 delta=0.01 fprout=0 pdits=1.4427E-15 \
    pditsl=0 pditsd=0 lambda=0 vtl=0 \
    lc=0 xn=0 alpha0=1.687407635666667E-3 lalpha0=-1.627859334572167E-10 \
    alpha1=0 beta0=31.24083182666667 lbeta0=-3.496153888186668E-7 aigbacc=1 \
    bigbacc=0 cigbacc=0 nigbacc=1 aigbinv=0.35 \
    bigbinv=0.03 cigbinv=6E-3 eigbinv=1.1 nigbinv=3 \
    aigc=0.43 bigc=0.054 cigc=0.075 aigsd=0.43 \
    bigsd=0.054 cigsd=0.075 dlcig=0 nigc=1 \
    poxedge=1 pigcd=1 ntox=1 toxref=4.148E-9 \
    agidl=0 bgidl=2.3E9 cgidl=0.5 egidl=0.8 \
    noia=9E41 noib=1E27 noic=8E11 em=4.1E7 \
    af=1 ef=1.2 kf=0 lintnoi=-3E-7 \
    tnoia=2.5E7 tnoib=9.9E6 ntnoi=1 rnoia=0.912 \
    rnoib=0.26 xpart=0 cgso=2.392894381e-10 cgdo=2.392894381e-10 \
    cgbo=1e-14 ckappas=0.6 cf=1E-14 clc=1E-7 \
    cle=0.6 dlc=1.21071E-8 dwc=2.6E-8 vfbcv=-1 \
    noff=3.8661 voffcv=-0.16994 acde=0.38008 moin=23.81 \
    cgsl=2.310725e-11 cgdl=2.310725e-11 ijthsrev=0.1 ijthsfwd=0.1 \
    xjbvs=1 bvs=11.9 jss=2.75E-3 jsws=6E-10 \
    cjs=0.00121 mjs=0.42197 mjsws=1E-3 cjsws=3.230311424e-11 \
    cjswgs=1.795291232e-10 mjswgs=0.8 pbs=0.7477 pbsws=0.1 \
    pbswgs=0.79644 xrcrg1=12 xrcrg2=1 rbpb=50 \
    rbpd=50 rbps=50 rbdb=50 rbsb=50 \
    gbmin=1E-12 tnom=30 ute=-2.841387833333333 lute=1.462012276083332E-7 \
    kt1=-0.295119316666667 lkt1=-2.874265065833337E-9 kt1l=0 kt2=0.02122778 \
    lkt2=-5.743292291000001E-9 ua1=-2.42902207E-9 lua1=3.816539507165E-16 ub1=2.4443796E-18 \
    lub1=-4.0006627012E-25 uc1=5.2148775E-12 luc1=-5.195283211249999E-19 at=6.394335E4 \
    lat=2.4945216175E-3 prt=0 njs=1.2928 xtis=2 \
    tpb=1.2287E-3 tpbsw=0 tpbswg=0 tcj=7.92E-4 \
    tcjsw=1E-5 tcjswg=0 tvoff=0 tvfbsdoff=0 \
    saref=1.1E-6 sbref=1.1E-6 wlod=0 ku0=-2.7E-8 \
    kvsat=0.2 kvth0=7.9E-9 tku0=0 llodku0=0 \
    wlodku0=1 llodvth=0 wlodvth=1 lku0=0 \
    wku0=0 pku0=0 lkvth0=0 wkvth0=3E-7 \
    pkvth0=0 stk2=0 lodk2=1 steta0=0 \
    lodeta0=1 rsh=497.54679376083186

// l=0.15 w=61.7 nf=27 -> bin nlowvt_model.8  rsh=482.4903 delvto=0 (folded into vth0)
model nlowvt_model__w61p7nf27 bsim4 \
    type=n version=4.50 binunit=2 mobmod=0 \
    capmod=2 rdsmod=0 igcmod=0 igbmod=0 \
    rbodymod=1 trnqsmod=0 acnqsmod=0 fnoimod=1 \
    tnoimod=1 diomod=1 tempmod=0 permod=1 \
    geomod=0 rgatemod=0 epsrox=3.9 toxe=4.148E-9 \
    toxm=4.148E-9 dtox=0 xj=1.5E-7 ndep=1.7E17 \
    ngate=9.999999999999999E22 nsd=1E20 rshg=0.1 phin=0 \
    wint=2.6e-08 wl=0 wln=1 ww=0 \
    wwn=1 wwl=0 lint=1.2025e-08 ll=0 \
    lln=1 lw=0 lwn=1 lwl=0 \
    llc=0 lwc=0 lwlc=0 wlc=0 \
    wwc=0 wwlc=0 dwg=-1.33E-8 dwb=-1.08E-8 \
    xl=0 xw=0 dmcg=0 dmdg=0 \
    dmcgt=0 xgw=0 xgl=0 ngcon=1 \
    vth0=0.249959346666667 lvth0=-1.985141612666671E-9 vfb=0 k1=1.011211866666667 \
    lk1=-4.876429660666666E-8 k2=-0.21737859252 lk2=1.7355223637994E-8 k3=1.65 \
    k3b=1.6 w0=1E-7 lpe0=2.3802E-7 lpeb=-4.9152E-8 \
    vbm=-3 dvtp0=0 dvtp1=0 dvt0=0.07665 \
    dvt1=0.1252 dvt2=-0.05637 dvt0w=0 dvt1w=5.3E6 \
    dvt2w=-0.032 vfbsdoff=0 u0=0.01421071555 lu0=2.166698264775001E-10 \
    ua=-3.496851672833332E-9 lua=1.729222681883582E-16 ub=4.57941585E-18 lub=-2.719028563075E-25 \
    uc=1.863698448333334E-10 luc=-2.261771620175834E-17 ud=0 up=0 \
    lp=1 eu=1.67 vsat=1.819855189500001E5 lvsat=-1.786254255252507E-3 \
    a0=0 ags=1.005218833333333 lags=3.096873294166675E-8 b0=0 \
    b1=0 keta=0.1569286063 lketa=-4.276737497598501E-8 a1=0 \
    a2=0.38689047 rdsw=103.65 rdswmin=0 rdw=0 \
    rdwmin=0 rsw=0 rswmin=0 prwb=0 \
    prwg=0 wr=1 voff=-0.11934831869 lvoff=5.296050099455504E-9 \
    voffl=0 minv=0 nfactor=0.723459400166666 lnfactor=3.583940752490084E-7 \
    eta0=0.067637351756667 leta0=1.529144370447834E-9 etab=-0.077077273825 letab=9.70788263825875E-9 \
    dsub=0.58180516425 ldsub=-4.053136043728748E-8 cit=5E-6 cdsc=3.8556E-37 \
    cdscb=-1.1484E-4 cdscd=4.7984E-6 pclm=0.086824416666667 lpclm=9.59179572083335E-9 \
    pdiblc1=3.583688213883334 lpdiblc1=-4.029261769551058E-7 pdiblc2=0.064735802833333 lpdiblc2=-7.957785851858334E-9 \
    pdiblcb=0 drout=3.4946 pscbe1=4.5E8 pscbe2=1E-8 \
    pvag=0 delta=0.01 fprout=0 pdits=1.4427E-15 \
    pditsl=0 pditsd=0 lambda=0 vtl=0 \
    lc=0 xn=0 alpha0=1.687407635666667E-3 lalpha0=-1.627859334572167E-10 \
    alpha1=0 beta0=31.24083182666667 lbeta0=-3.496153888186668E-7 aigbacc=1 \
    bigbacc=0 cigbacc=0 nigbacc=1 aigbinv=0.35 \
    bigbinv=0.03 cigbinv=6E-3 eigbinv=1.1 nigbinv=3 \
    aigc=0.43 bigc=0.054 cigc=0.075 aigsd=0.43 \
    bigsd=0.054 cigsd=0.075 dlcig=0 nigc=1 \
    poxedge=1 pigcd=1 ntox=1 toxref=4.148E-9 \
    agidl=0 bgidl=2.3E9 cgidl=0.5 egidl=0.8 \
    noia=9E41 noib=1E27 noic=8E11 em=4.1E7 \
    af=1 ef=1.2 kf=0 lintnoi=-3E-7 \
    tnoia=2.5E7 tnoib=9.9E6 ntnoi=1 rnoia=0.912 \
    rnoib=0.26 xpart=0 cgso=2.392894381e-10 cgdo=2.392894381e-10 \
    cgbo=1e-14 ckappas=0.6 cf=1E-14 clc=1E-7 \
    cle=0.6 dlc=1.21071E-8 dwc=2.6E-8 vfbcv=-1 \
    noff=3.8661 voffcv=-0.16994 acde=0.38008 moin=23.81 \
    cgsl=2.310725e-11 cgdl=2.310725e-11 ijthsrev=0.1 ijthsfwd=0.1 \
    xjbvs=1 bvs=11.9 jss=2.75E-3 jsws=6E-10 \
    cjs=0.00121 mjs=0.42197 mjsws=1E-3 cjsws=3.230311424e-11 \
    cjswgs=1.795291232e-10 mjswgs=0.8 pbs=0.7477 pbsws=0.1 \
    pbswgs=0.79644 xrcrg1=12 xrcrg2=1 rbpb=50 \
    rbpd=50 rbps=50 rbdb=50 rbsb=50 \
    gbmin=1E-12 tnom=30 ute=-2.841387833333333 lute=1.462012276083332E-7 \
    kt1=-0.295119316666667 lkt1=-2.874265065833337E-9 kt1l=0 kt2=0.02122778 \
    lkt2=-5.743292291000001E-9 ua1=-2.42902207E-9 lua1=3.816539507165E-16 ub1=2.4443796E-18 \
    lub1=-4.0006627012E-25 uc1=5.2148775E-12 luc1=-5.195283211249999E-19 at=6.394335E4 \
    lat=2.4945216175E-3 prt=0 njs=1.2928 xtis=2 \
    tpb=1.2287E-3 tpbsw=0 tpbswg=0 tcj=7.92E-4 \
    tcjsw=1E-5 tcjswg=0 tvoff=0 tvfbsdoff=0 \
    saref=1.1E-6 sbref=1.1E-6 wlod=0 ku0=-2.7E-8 \
    kvsat=0.2 kvth0=7.9E-9 tku0=0 llodku0=0 \
    wlodku0=1 llodvth=0 wlodvth=1 lku0=0 \
    wku0=0 pku0=0 lkvth0=0 wkvth0=3E-7 \
    pkvth0=0 stk2=0 lodk2=1 steta0=0 \
    lodeta0=1 rsh=482.49027552674227

// l=0.15 w=61.7 nf=29 -> bin nlowvt_model.8  rsh=485.3784 delvto=0 (folded into vth0)
model nlowvt_model__w61p7nf29 bsim4 \
    type=n version=4.50 binunit=2 mobmod=0 \
    capmod=2 rdsmod=0 igcmod=0 igbmod=0 \
    rbodymod=1 trnqsmod=0 acnqsmod=0 fnoimod=1 \
    tnoimod=1 diomod=1 tempmod=0 permod=1 \
    geomod=0 rgatemod=0 epsrox=3.9 toxe=4.148E-9 \
    toxm=4.148E-9 dtox=0 xj=1.5E-7 ndep=1.7E17 \
    ngate=9.999999999999999E22 nsd=1E20 rshg=0.1 phin=0 \
    wint=2.6e-08 wl=0 wln=1 ww=0 \
    wwn=1 wwl=0 lint=1.2025e-08 ll=0 \
    lln=1 lw=0 lwn=1 lwl=0 \
    llc=0 lwc=0 lwlc=0 wlc=0 \
    wwc=0 wwlc=0 dwg=-1.33E-8 dwb=-1.08E-8 \
    xl=0 xw=0 dmcg=0 dmdg=0 \
    dmcgt=0 xgw=0 xgl=0 ngcon=1 \
    vth0=0.249959346666667 lvth0=-1.985141612666671E-9 vfb=0 k1=1.011211866666667 \
    lk1=-4.876429660666666E-8 k2=-0.21737859252 lk2=1.7355223637994E-8 k3=1.65 \
    k3b=1.6 w0=1E-7 lpe0=2.3802E-7 lpeb=-4.9152E-8 \
    vbm=-3 dvtp0=0 dvtp1=0 dvt0=0.07665 \
    dvt1=0.1252 dvt2=-0.05637 dvt0w=0 dvt1w=5.3E6 \
    dvt2w=-0.032 vfbsdoff=0 u0=0.01421071555 lu0=2.166698264775001E-10 \
    ua=-3.496851672833332E-9 lua=1.729222681883582E-16 ub=4.57941585E-18 lub=-2.719028563075E-25 \
    uc=1.863698448333334E-10 luc=-2.261771620175834E-17 ud=0 up=0 \
    lp=1 eu=1.67 vsat=1.819855189500001E5 lvsat=-1.786254255252507E-3 \
    a0=0 ags=1.005218833333333 lags=3.096873294166675E-8 b0=0 \
    b1=0 keta=0.1569286063 lketa=-4.276737497598501E-8 a1=0 \
    a2=0.38689047 rdsw=103.65 rdswmin=0 rdw=0 \
    rdwmin=0 rsw=0 rswmin=0 prwb=0 \
    prwg=0 wr=1 voff=-0.11934831869 lvoff=5.296050099455504E-9 \
    voffl=0 minv=0 nfactor=0.723459400166666 lnfactor=3.583940752490084E-7 \
    eta0=0.067637351756667 leta0=1.529144370447834E-9 etab=-0.077077273825 letab=9.70788263825875E-9 \
    dsub=0.58180516425 ldsub=-4.053136043728748E-8 cit=5E-6 cdsc=3.8556E-37 \
    cdscb=-1.1484E-4 cdscd=4.7984E-6 pclm=0.086824416666667 lpclm=9.59179572083335E-9 \
    pdiblc1=3.583688213883334 lpdiblc1=-4.029261769551058E-7 pdiblc2=0.064735802833333 lpdiblc2=-7.957785851858334E-9 \
    pdiblcb=0 drout=3.4946 pscbe1=4.5E8 pscbe2=1E-8 \
    pvag=0 delta=0.01 fprout=0 pdits=1.4427E-15 \
    pditsl=0 pditsd=0 lambda=0 vtl=0 \
    lc=0 xn=0 alpha0=1.687407635666667E-3 lalpha0=-1.627859334572167E-10 \
    alpha1=0 beta0=31.24083182666667 lbeta0=-3.496153888186668E-7 aigbacc=1 \
    bigbacc=0 cigbacc=0 nigbacc=1 aigbinv=0.35 \
    bigbinv=0.03 cigbinv=6E-3 eigbinv=1.1 nigbinv=3 \
    aigc=0.43 bigc=0.054 cigc=0.075 aigsd=0.43 \
    bigsd=0.054 cigsd=0.075 dlcig=0 nigc=1 \
    poxedge=1 pigcd=1 ntox=1 toxref=4.148E-9 \
    agidl=0 bgidl=2.3E9 cgidl=0.5 egidl=0.8 \
    noia=9E41 noib=1E27 noic=8E11 em=4.1E7 \
    af=1 ef=1.2 kf=0 lintnoi=-3E-7 \
    tnoia=2.5E7 tnoib=9.9E6 ntnoi=1 rnoia=0.912 \
    rnoib=0.26 xpart=0 cgso=2.392894381e-10 cgdo=2.392894381e-10 \
    cgbo=1e-14 ckappas=0.6 cf=1E-14 clc=1E-7 \
    cle=0.6 dlc=1.21071E-8 dwc=2.6E-8 vfbcv=-1 \
    noff=3.8661 voffcv=-0.16994 acde=0.38008 moin=23.81 \
    cgsl=2.310725e-11 cgdl=2.310725e-11 ijthsrev=0.1 ijthsfwd=0.1 \
    xjbvs=1 bvs=11.9 jss=2.75E-3 jsws=6E-10 \
    cjs=0.00121 mjs=0.42197 mjsws=1E-3 cjsws=3.230311424e-11 \
    cjswgs=1.795291232e-10 mjswgs=0.8 pbs=0.7477 pbsws=0.1 \
    pbswgs=0.79644 xrcrg1=12 xrcrg2=1 rbpb=50 \
    rbpd=50 rbps=50 rbdb=50 rbsb=50 \
    gbmin=1E-12 tnom=30 ute=-2.841387833333333 lute=1.462012276083332E-7 \
    kt1=-0.295119316666667 lkt1=-2.874265065833337E-9 kt1l=0 kt2=0.02122778 \
    lkt2=-5.743292291000001E-9 ua1=-2.42902207E-9 lua1=3.816539507165E-16 ub1=2.4443796E-18 \
    lub1=-4.0006627012E-25 uc1=5.2148775E-12 luc1=-5.195283211249999E-19 at=6.394335E4 \
    lat=2.4945216175E-3 prt=0 njs=1.2928 xtis=2 \
    tpb=1.2287E-3 tpbsw=0 tpbswg=0 tcj=7.92E-4 \
    tcjsw=1E-5 tcjswg=0 tvoff=0 tvfbsdoff=0 \
    saref=1.1E-6 sbref=1.1E-6 wlod=0 ku0=-2.7E-8 \
    kvsat=0.2 kvth0=7.9E-9 tku0=0 llodku0=0 \
    wlodku0=1 llodvth=0 wlodvth=1 lku0=0 \
    wku0=0 pku0=0 lkvth0=0 wkvth0=3E-7 \
    pkvth0=0 stk2=0 lodk2=1 steta0=0 \
    lodeta0=1 rsh=485.3784440842788

// l=0.15 w=61.7 nf=33 -> bin nlowvt_model.8  rsh=491.1548 delvto=0 (folded into vth0)
model nlowvt_model__w61p7nf33 bsim4 \
    type=n version=4.50 binunit=2 mobmod=0 \
    capmod=2 rdsmod=0 igcmod=0 igbmod=0 \
    rbodymod=1 trnqsmod=0 acnqsmod=0 fnoimod=1 \
    tnoimod=1 diomod=1 tempmod=0 permod=1 \
    geomod=0 rgatemod=0 epsrox=3.9 toxe=4.148E-9 \
    toxm=4.148E-9 dtox=0 xj=1.5E-7 ndep=1.7E17 \
    ngate=9.999999999999999E22 nsd=1E20 rshg=0.1 phin=0 \
    wint=2.6e-08 wl=0 wln=1 ww=0 \
    wwn=1 wwl=0 lint=1.2025e-08 ll=0 \
    lln=1 lw=0 lwn=1 lwl=0 \
    llc=0 lwc=0 lwlc=0 wlc=0 \
    wwc=0 wwlc=0 dwg=-1.33E-8 dwb=-1.08E-8 \
    xl=0 xw=0 dmcg=0 dmdg=0 \
    dmcgt=0 xgw=0 xgl=0 ngcon=1 \
    vth0=0.249959346666667 lvth0=-1.985141612666671E-9 vfb=0 k1=1.011211866666667 \
    lk1=-4.876429660666666E-8 k2=-0.21737859252 lk2=1.7355223637994E-8 k3=1.65 \
    k3b=1.6 w0=1E-7 lpe0=2.3802E-7 lpeb=-4.9152E-8 \
    vbm=-3 dvtp0=0 dvtp1=0 dvt0=0.07665 \
    dvt1=0.1252 dvt2=-0.05637 dvt0w=0 dvt1w=5.3E6 \
    dvt2w=-0.032 vfbsdoff=0 u0=0.01421071555 lu0=2.166698264775001E-10 \
    ua=-3.496851672833332E-9 lua=1.729222681883582E-16 ub=4.57941585E-18 lub=-2.719028563075E-25 \
    uc=1.863698448333334E-10 luc=-2.261771620175834E-17 ud=0 up=0 \
    lp=1 eu=1.67 vsat=1.819855189500001E5 lvsat=-1.786254255252507E-3 \
    a0=0 ags=1.005218833333333 lags=3.096873294166675E-8 b0=0 \
    b1=0 keta=0.1569286063 lketa=-4.276737497598501E-8 a1=0 \
    a2=0.38689047 rdsw=103.65 rdswmin=0 rdw=0 \
    rdwmin=0 rsw=0 rswmin=0 prwb=0 \
    prwg=0 wr=1 voff=-0.11934831869 lvoff=5.296050099455504E-9 \
    voffl=0 minv=0 nfactor=0.723459400166666 lnfactor=3.583940752490084E-7 \
    eta0=0.067637351756667 leta0=1.529144370447834E-9 etab=-0.077077273825 letab=9.70788263825875E-9 \
    dsub=0.58180516425 ldsub=-4.053136043728748E-8 cit=5E-6 cdsc=3.8556E-37 \
    cdscb=-1.1484E-4 cdscd=4.7984E-6 pclm=0.086824416666667 lpclm=9.59179572083335E-9 \
    pdiblc1=3.583688213883334 lpdiblc1=-4.029261769551058E-7 pdiblc2=0.064735802833333 lpdiblc2=-7.957785851858334E-9 \
    pdiblcb=0 drout=3.4946 pscbe1=4.5E8 pscbe2=1E-8 \
    pvag=0 delta=0.01 fprout=0 pdits=1.4427E-15 \
    pditsl=0 pditsd=0 lambda=0 vtl=0 \
    lc=0 xn=0 alpha0=1.687407635666667E-3 lalpha0=-1.627859334572167E-10 \
    alpha1=0 beta0=31.24083182666667 lbeta0=-3.496153888186668E-7 aigbacc=1 \
    bigbacc=0 cigbacc=0 nigbacc=1 aigbinv=0.35 \
    bigbinv=0.03 cigbinv=6E-3 eigbinv=1.1 nigbinv=3 \
    aigc=0.43 bigc=0.054 cigc=0.075 aigsd=0.43 \
    bigsd=0.054 cigsd=0.075 dlcig=0 nigc=1 \
    poxedge=1 pigcd=1 ntox=1 toxref=4.148E-9 \
    agidl=0 bgidl=2.3E9 cgidl=0.5 egidl=0.8 \
    noia=9E41 noib=1E27 noic=8E11 em=4.1E7 \
    af=1 ef=1.2 kf=0 lintnoi=-3E-7 \
    tnoia=2.5E7 tnoib=9.9E6 ntnoi=1 rnoia=0.912 \
    rnoib=0.26 xpart=0 cgso=2.392894381e-10 cgdo=2.392894381e-10 \
    cgbo=1e-14 ckappas=0.6 cf=1E-14 clc=1E-7 \
    cle=0.6 dlc=1.21071E-8 dwc=2.6E-8 vfbcv=-1 \
    noff=3.8661 voffcv=-0.16994 acde=0.38008 moin=23.81 \
    cgsl=2.310725e-11 cgdl=2.310725e-11 ijthsrev=0.1 ijthsfwd=0.1 \
    xjbvs=1 bvs=11.9 jss=2.75E-3 jsws=6E-10 \
    cjs=0.00121 mjs=0.42197 mjsws=1E-3 cjsws=3.230311424e-11 \
    cjswgs=1.795291232e-10 mjswgs=0.8 pbs=0.7477 pbsws=0.1 \
    pbswgs=0.79644 xrcrg1=12 xrcrg2=1 rbpb=50 \
    rbpd=50 rbps=50 rbdb=50 rbsb=50 \
    gbmin=1E-12 tnom=30 ute=-2.841387833333333 lute=1.462012276083332E-7 \
    kt1=-0.295119316666667 lkt1=-2.874265065833337E-9 kt1l=0 kt2=0.02122778 \
    lkt2=-5.743292291000001E-9 ua1=-2.42902207E-9 lua1=3.816539507165E-16 ub1=2.4443796E-18 \
    lub1=-4.0006627012E-25 uc1=5.2148775E-12 luc1=-5.195283211249999E-19 at=6.394335E4 \
    lat=2.4945216175E-3 prt=0 njs=1.2928 xtis=2 \
    tpb=1.2287E-3 tpbsw=0 tpbswg=0 tcj=7.92E-4 \
    tcjsw=1E-5 tcjswg=0 tvoff=0 tvfbsdoff=0 \
    saref=1.1E-6 sbref=1.1E-6 wlod=0 ku0=-2.7E-8 \
    kvsat=0.2 kvth0=7.9E-9 tku0=0 llodku0=0 \
    wlodku0=1 llodvth=0 wlodvth=1 lku0=0 \
    wku0=0 pku0=0 lkvth0=0 wkvth0=3E-7 \
    pkvth0=0 stk2=0 lodk2=1 steta0=0 \
    lodeta0=1 rsh=491.1547811993517

// l=0.15 w=61.7 nf=35 -> bin nlowvt_model.8  rsh=494.0429 delvto=0 (folded into vth0)
model nlowvt_model__w61p7nf35 bsim4 \
    type=n version=4.50 binunit=2 mobmod=0 \
    capmod=2 rdsmod=0 igcmod=0 igbmod=0 \
    rbodymod=1 trnqsmod=0 acnqsmod=0 fnoimod=1 \
    tnoimod=1 diomod=1 tempmod=0 permod=1 \
    geomod=0 rgatemod=0 epsrox=3.9 toxe=4.148E-9 \
    toxm=4.148E-9 dtox=0 xj=1.5E-7 ndep=1.7E17 \
    ngate=9.999999999999999E22 nsd=1E20 rshg=0.1 phin=0 \
    wint=2.6e-08 wl=0 wln=1 ww=0 \
    wwn=1 wwl=0 lint=1.2025e-08 ll=0 \
    lln=1 lw=0 lwn=1 lwl=0 \
    llc=0 lwc=0 lwlc=0 wlc=0 \
    wwc=0 wwlc=0 dwg=-1.33E-8 dwb=-1.08E-8 \
    xl=0 xw=0 dmcg=0 dmdg=0 \
    dmcgt=0 xgw=0 xgl=0 ngcon=1 \
    vth0=0.249959346666667 lvth0=-1.985141612666671E-9 vfb=0 k1=1.011211866666667 \
    lk1=-4.876429660666666E-8 k2=-0.21737859252 lk2=1.7355223637994E-8 k3=1.65 \
    k3b=1.6 w0=1E-7 lpe0=2.3802E-7 lpeb=-4.9152E-8 \
    vbm=-3 dvtp0=0 dvtp1=0 dvt0=0.07665 \
    dvt1=0.1252 dvt2=-0.05637 dvt0w=0 dvt1w=5.3E6 \
    dvt2w=-0.032 vfbsdoff=0 u0=0.01421071555 lu0=2.166698264775001E-10 \
    ua=-3.496851672833332E-9 lua=1.729222681883582E-16 ub=4.57941585E-18 lub=-2.719028563075E-25 \
    uc=1.863698448333334E-10 luc=-2.261771620175834E-17 ud=0 up=0 \
    lp=1 eu=1.67 vsat=1.819855189500001E5 lvsat=-1.786254255252507E-3 \
    a0=0 ags=1.005218833333333 lags=3.096873294166675E-8 b0=0 \
    b1=0 keta=0.1569286063 lketa=-4.276737497598501E-8 a1=0 \
    a2=0.38689047 rdsw=103.65 rdswmin=0 rdw=0 \
    rdwmin=0 rsw=0 rswmin=0 prwb=0 \
    prwg=0 wr=1 voff=-0.11934831869 lvoff=5.296050099455504E-9 \
    voffl=0 minv=0 nfactor=0.723459400166666 lnfactor=3.583940752490084E-7 \
    eta0=0.067637351756667 leta0=1.529144370447834E-9 etab=-0.077077273825 letab=9.70788263825875E-9 \
    dsub=0.58180516425 ldsub=-4.053136043728748E-8 cit=5E-6 cdsc=3.8556E-37 \
    cdscb=-1.1484E-4 cdscd=4.7984E-6 pclm=0.086824416666667 lpclm=9.59179572083335E-9 \
    pdiblc1=3.583688213883334 lpdiblc1=-4.029261769551058E-7 pdiblc2=0.064735802833333 lpdiblc2=-7.957785851858334E-9 \
    pdiblcb=0 drout=3.4946 pscbe1=4.5E8 pscbe2=1E-8 \
    pvag=0 delta=0.01 fprout=0 pdits=1.4427E-15 \
    pditsl=0 pditsd=0 lambda=0 vtl=0 \
    lc=0 xn=0 alpha0=1.687407635666667E-3 lalpha0=-1.627859334572167E-10 \
    alpha1=0 beta0=31.24083182666667 lbeta0=-3.496153888186668E-7 aigbacc=1 \
    bigbacc=0 cigbacc=0 nigbacc=1 aigbinv=0.35 \
    bigbinv=0.03 cigbinv=6E-3 eigbinv=1.1 nigbinv=3 \
    aigc=0.43 bigc=0.054 cigc=0.075 aigsd=0.43 \
    bigsd=0.054 cigsd=0.075 dlcig=0 nigc=1 \
    poxedge=1 pigcd=1 ntox=1 toxref=4.148E-9 \
    agidl=0 bgidl=2.3E9 cgidl=0.5 egidl=0.8 \
    noia=9E41 noib=1E27 noic=8E11 em=4.1E7 \
    af=1 ef=1.2 kf=0 lintnoi=-3E-7 \
    tnoia=2.5E7 tnoib=9.9E6 ntnoi=1 rnoia=0.912 \
    rnoib=0.26 xpart=0 cgso=2.392894381e-10 cgdo=2.392894381e-10 \
    cgbo=1e-14 ckappas=0.6 cf=1E-14 clc=1E-7 \
    cle=0.6 dlc=1.21071E-8 dwc=2.6E-8 vfbcv=-1 \
    noff=3.8661 voffcv=-0.16994 acde=0.38008 moin=23.81 \
    cgsl=2.310725e-11 cgdl=2.310725e-11 ijthsrev=0.1 ijthsfwd=0.1 \
    xjbvs=1 bvs=11.9 jss=2.75E-3 jsws=6E-10 \
    cjs=0.00121 mjs=0.42197 mjsws=1E-3 cjsws=3.230311424e-11 \
    cjswgs=1.795291232e-10 mjswgs=0.8 pbs=0.7477 pbsws=0.1 \
    pbswgs=0.79644 xrcrg1=12 xrcrg2=1 rbpb=50 \
    rbpd=50 rbps=50 rbdb=50 rbsb=50 \
    gbmin=1E-12 tnom=30 ute=-2.841387833333333 lute=1.462012276083332E-7 \
    kt1=-0.295119316666667 lkt1=-2.874265065833337E-9 kt1l=0 kt2=0.02122778 \
    lkt2=-5.743292291000001E-9 ua1=-2.42902207E-9 lua1=3.816539507165E-16 ub1=2.4443796E-18 \
    lub1=-4.0006627012E-25 uc1=5.2148775E-12 luc1=-5.195283211249999E-19 at=6.394335E4 \
    lat=2.4945216175E-3 prt=0 njs=1.2928 xtis=2 \
    tpb=1.2287E-3 tpbsw=0 tpbswg=0 tcj=7.92E-4 \
    tcjsw=1E-5 tcjswg=0 tvoff=0 tvfbsdoff=0 \
    saref=1.1E-6 sbref=1.1E-6 wlod=0 ku0=-2.7E-8 \
    kvsat=0.2 kvth0=7.9E-9 tku0=0 llodku0=0 \
    wlodku0=1 llodvth=0 wlodvth=1 lku0=0 \
    wku0=0 pku0=0 lkvth0=0 wkvth0=3E-7 \
    pkvth0=0 stk2=0 lodk2=1 steta0=0 \
    lodeta0=1 rsh=494.04294975688816

// l=0.15 w=65.7 nf=27 -> bin nlowvt_model.8  rsh=480.1164 delvto=0 (folded into vth0)
model nlowvt_model__w65p7nf27 bsim4 \
    type=n version=4.50 binunit=2 mobmod=0 \
    capmod=2 rdsmod=0 igcmod=0 igbmod=0 \
    rbodymod=1 trnqsmod=0 acnqsmod=0 fnoimod=1 \
    tnoimod=1 diomod=1 tempmod=0 permod=1 \
    geomod=0 rgatemod=0 epsrox=3.9 toxe=4.148E-9 \
    toxm=4.148E-9 dtox=0 xj=1.5E-7 ndep=1.7E17 \
    ngate=9.999999999999999E22 nsd=1E20 rshg=0.1 phin=0 \
    wint=2.6e-08 wl=0 wln=1 ww=0 \
    wwn=1 wwl=0 lint=1.2025e-08 ll=0 \
    lln=1 lw=0 lwn=1 lwl=0 \
    llc=0 lwc=0 lwlc=0 wlc=0 \
    wwc=0 wwlc=0 dwg=-1.33E-8 dwb=-1.08E-8 \
    xl=0 xw=0 dmcg=0 dmdg=0 \
    dmcgt=0 xgw=0 xgl=0 ngcon=1 \
    vth0=0.249959346666667 lvth0=-1.985141612666671E-9 vfb=0 k1=1.011211866666667 \
    lk1=-4.876429660666666E-8 k2=-0.21737859252 lk2=1.7355223637994E-8 k3=1.65 \
    k3b=1.6 w0=1E-7 lpe0=2.3802E-7 lpeb=-4.9152E-8 \
    vbm=-3 dvtp0=0 dvtp1=0 dvt0=0.07665 \
    dvt1=0.1252 dvt2=-0.05637 dvt0w=0 dvt1w=5.3E6 \
    dvt2w=-0.032 vfbsdoff=0 u0=0.01421071555 lu0=2.166698264775001E-10 \
    ua=-3.496851672833332E-9 lua=1.729222681883582E-16 ub=4.57941585E-18 lub=-2.719028563075E-25 \
    uc=1.863698448333334E-10 luc=-2.261771620175834E-17 ud=0 up=0 \
    lp=1 eu=1.67 vsat=1.819855189500001E5 lvsat=-1.786254255252507E-3 \
    a0=0 ags=1.005218833333333 lags=3.096873294166675E-8 b0=0 \
    b1=0 keta=0.1569286063 lketa=-4.276737497598501E-8 a1=0 \
    a2=0.38689047 rdsw=103.65 rdswmin=0 rdw=0 \
    rdwmin=0 rsw=0 rswmin=0 prwb=0 \
    prwg=0 wr=1 voff=-0.11934831869 lvoff=5.296050099455504E-9 \
    voffl=0 minv=0 nfactor=0.723459400166666 lnfactor=3.583940752490084E-7 \
    eta0=0.067637351756667 leta0=1.529144370447834E-9 etab=-0.077077273825 letab=9.70788263825875E-9 \
    dsub=0.58180516425 ldsub=-4.053136043728748E-8 cit=5E-6 cdsc=3.8556E-37 \
    cdscb=-1.1484E-4 cdscd=4.7984E-6 pclm=0.086824416666667 lpclm=9.59179572083335E-9 \
    pdiblc1=3.583688213883334 lpdiblc1=-4.029261769551058E-7 pdiblc2=0.064735802833333 lpdiblc2=-7.957785851858334E-9 \
    pdiblcb=0 drout=3.4946 pscbe1=4.5E8 pscbe2=1E-8 \
    pvag=0 delta=0.01 fprout=0 pdits=1.4427E-15 \
    pditsl=0 pditsd=0 lambda=0 vtl=0 \
    lc=0 xn=0 alpha0=1.687407635666667E-3 lalpha0=-1.627859334572167E-10 \
    alpha1=0 beta0=31.24083182666667 lbeta0=-3.496153888186668E-7 aigbacc=1 \
    bigbacc=0 cigbacc=0 nigbacc=1 aigbinv=0.35 \
    bigbinv=0.03 cigbinv=6E-3 eigbinv=1.1 nigbinv=3 \
    aigc=0.43 bigc=0.054 cigc=0.075 aigsd=0.43 \
    bigsd=0.054 cigsd=0.075 dlcig=0 nigc=1 \
    poxedge=1 pigcd=1 ntox=1 toxref=4.148E-9 \
    agidl=0 bgidl=2.3E9 cgidl=0.5 egidl=0.8 \
    noia=9E41 noib=1E27 noic=8E11 em=4.1E7 \
    af=1 ef=1.2 kf=0 lintnoi=-3E-7 \
    tnoia=2.5E7 tnoib=9.9E6 ntnoi=1 rnoia=0.912 \
    rnoib=0.26 xpart=0 cgso=2.392894381e-10 cgdo=2.392894381e-10 \
    cgbo=1e-14 ckappas=0.6 cf=1E-14 clc=1E-7 \
    cle=0.6 dlc=1.21071E-8 dwc=2.6E-8 vfbcv=-1 \
    noff=3.8661 voffcv=-0.16994 acde=0.38008 moin=23.81 \
    cgsl=2.310725e-11 cgdl=2.310725e-11 ijthsrev=0.1 ijthsfwd=0.1 \
    xjbvs=1 bvs=11.9 jss=2.75E-3 jsws=6E-10 \
    cjs=0.00121 mjs=0.42197 mjsws=1E-3 cjsws=3.230311424e-11 \
    cjswgs=1.795291232e-10 mjswgs=0.8 pbs=0.7477 pbsws=0.1 \
    pbswgs=0.79644 xrcrg1=12 xrcrg2=1 rbpb=50 \
    rbpd=50 rbps=50 rbdb=50 rbsb=50 \
    gbmin=1E-12 tnom=30 ute=-2.841387833333333 lute=1.462012276083332E-7 \
    kt1=-0.295119316666667 lkt1=-2.874265065833337E-9 kt1l=0 kt2=0.02122778 \
    lkt2=-5.743292291000001E-9 ua1=-2.42902207E-9 lua1=3.816539507165E-16 ub1=2.4443796E-18 \
    lub1=-4.0006627012E-25 uc1=5.2148775E-12 luc1=-5.195283211249999E-19 at=6.394335E4 \
    lat=2.4945216175E-3 prt=0 njs=1.2928 xtis=2 \
    tpb=1.2287E-3 tpbsw=0 tpbswg=0 tcj=7.92E-4 \
    tcjsw=1E-5 tcjswg=0 tvoff=0 tvfbsdoff=0 \
    saref=1.1E-6 sbref=1.1E-6 wlod=0 ku0=-2.7E-8 \
    kvsat=0.2 kvth0=7.9E-9 tku0=0 llodku0=0 \
    wlodku0=1 llodvth=0 wlodvth=1 lku0=0 \
    wku0=0 pku0=0 lkvth0=0 wkvth0=3E-7 \
    pkvth0=0 stk2=0 lodk2=1 steta0=0 \
    lodeta0=1 rsh=480.1164383561644

// l=0.15 w=65.7 nf=29 -> bin nlowvt_model.8  rsh=482.8288 delvto=0 (folded into vth0)
model nlowvt_model__w65p7nf29 bsim4 \
    type=n version=4.50 binunit=2 mobmod=0 \
    capmod=2 rdsmod=0 igcmod=0 igbmod=0 \
    rbodymod=1 trnqsmod=0 acnqsmod=0 fnoimod=1 \
    tnoimod=1 diomod=1 tempmod=0 permod=1 \
    geomod=0 rgatemod=0 epsrox=3.9 toxe=4.148E-9 \
    toxm=4.148E-9 dtox=0 xj=1.5E-7 ndep=1.7E17 \
    ngate=9.999999999999999E22 nsd=1E20 rshg=0.1 phin=0 \
    wint=2.6e-08 wl=0 wln=1 ww=0 \
    wwn=1 wwl=0 lint=1.2025e-08 ll=0 \
    lln=1 lw=0 lwn=1 lwl=0 \
    llc=0 lwc=0 lwlc=0 wlc=0 \
    wwc=0 wwlc=0 dwg=-1.33E-8 dwb=-1.08E-8 \
    xl=0 xw=0 dmcg=0 dmdg=0 \
    dmcgt=0 xgw=0 xgl=0 ngcon=1 \
    vth0=0.249959346666667 lvth0=-1.985141612666671E-9 vfb=0 k1=1.011211866666667 \
    lk1=-4.876429660666666E-8 k2=-0.21737859252 lk2=1.7355223637994E-8 k3=1.65 \
    k3b=1.6 w0=1E-7 lpe0=2.3802E-7 lpeb=-4.9152E-8 \
    vbm=-3 dvtp0=0 dvtp1=0 dvt0=0.07665 \
    dvt1=0.1252 dvt2=-0.05637 dvt0w=0 dvt1w=5.3E6 \
    dvt2w=-0.032 vfbsdoff=0 u0=0.01421071555 lu0=2.166698264775001E-10 \
    ua=-3.496851672833332E-9 lua=1.729222681883582E-16 ub=4.57941585E-18 lub=-2.719028563075E-25 \
    uc=1.863698448333334E-10 luc=-2.261771620175834E-17 ud=0 up=0 \
    lp=1 eu=1.67 vsat=1.819855189500001E5 lvsat=-1.786254255252507E-3 \
    a0=0 ags=1.005218833333333 lags=3.096873294166675E-8 b0=0 \
    b1=0 keta=0.1569286063 lketa=-4.276737497598501E-8 a1=0 \
    a2=0.38689047 rdsw=103.65 rdswmin=0 rdw=0 \
    rdwmin=0 rsw=0 rswmin=0 prwb=0 \
    prwg=0 wr=1 voff=-0.11934831869 lvoff=5.296050099455504E-9 \
    voffl=0 minv=0 nfactor=0.723459400166666 lnfactor=3.583940752490084E-7 \
    eta0=0.067637351756667 leta0=1.529144370447834E-9 etab=-0.077077273825 letab=9.70788263825875E-9 \
    dsub=0.58180516425 ldsub=-4.053136043728748E-8 cit=5E-6 cdsc=3.8556E-37 \
    cdscb=-1.1484E-4 cdscd=4.7984E-6 pclm=0.086824416666667 lpclm=9.59179572083335E-9 \
    pdiblc1=3.583688213883334 lpdiblc1=-4.029261769551058E-7 pdiblc2=0.064735802833333 lpdiblc2=-7.957785851858334E-9 \
    pdiblcb=0 drout=3.4946 pscbe1=4.5E8 pscbe2=1E-8 \
    pvag=0 delta=0.01 fprout=0 pdits=1.4427E-15 \
    pditsl=0 pditsd=0 lambda=0 vtl=0 \
    lc=0 xn=0 alpha0=1.687407635666667E-3 lalpha0=-1.627859334572167E-10 \
    alpha1=0 beta0=31.24083182666667 lbeta0=-3.496153888186668E-7 aigbacc=1 \
    bigbacc=0 cigbacc=0 nigbacc=1 aigbinv=0.35 \
    bigbinv=0.03 cigbinv=6E-3 eigbinv=1.1 nigbinv=3 \
    aigc=0.43 bigc=0.054 cigc=0.075 aigsd=0.43 \
    bigsd=0.054 cigsd=0.075 dlcig=0 nigc=1 \
    poxedge=1 pigcd=1 ntox=1 toxref=4.148E-9 \
    agidl=0 bgidl=2.3E9 cgidl=0.5 egidl=0.8 \
    noia=9E41 noib=1E27 noic=8E11 em=4.1E7 \
    af=1 ef=1.2 kf=0 lintnoi=-3E-7 \
    tnoia=2.5E7 tnoib=9.9E6 ntnoi=1 rnoia=0.912 \
    rnoib=0.26 xpart=0 cgso=2.392894381e-10 cgdo=2.392894381e-10 \
    cgbo=1e-14 ckappas=0.6 cf=1E-14 clc=1E-7 \
    cle=0.6 dlc=1.21071E-8 dwc=2.6E-8 vfbcv=-1 \
    noff=3.8661 voffcv=-0.16994 acde=0.38008 moin=23.81 \
    cgsl=2.310725e-11 cgdl=2.310725e-11 ijthsrev=0.1 ijthsfwd=0.1 \
    xjbvs=1 bvs=11.9 jss=2.75E-3 jsws=6E-10 \
    cjs=0.00121 mjs=0.42197 mjsws=1E-3 cjsws=3.230311424e-11 \
    cjswgs=1.795291232e-10 mjswgs=0.8 pbs=0.7477 pbsws=0.1 \
    pbswgs=0.79644 xrcrg1=12 xrcrg2=1 rbpb=50 \
    rbpd=50 rbps=50 rbdb=50 rbsb=50 \
    gbmin=1E-12 tnom=30 ute=-2.841387833333333 lute=1.462012276083332E-7 \
    kt1=-0.295119316666667 lkt1=-2.874265065833337E-9 kt1l=0 kt2=0.02122778 \
    lkt2=-5.743292291000001E-9 ua1=-2.42902207E-9 lua1=3.816539507165E-16 ub1=2.4443796E-18 \
    lub1=-4.0006627012E-25 uc1=5.2148775E-12 luc1=-5.195283211249999E-19 at=6.394335E4 \
    lat=2.4945216175E-3 prt=0 njs=1.2928 xtis=2 \
    tpb=1.2287E-3 tpbsw=0 tpbswg=0 tcj=7.92E-4 \
    tcjsw=1E-5 tcjswg=0 tvoff=0 tvfbsdoff=0 \
    saref=1.1E-6 sbref=1.1E-6 wlod=0 ku0=-2.7E-8 \
    kvsat=0.2 kvth0=7.9E-9 tku0=0 llodku0=0 \
    wlodku0=1 llodvth=0 wlodvth=1 lku0=0 \
    wku0=0 pku0=0 lkvth0=0 wkvth0=3E-7 \
    pkvth0=0 stk2=0 lodk2=1 steta0=0 \
    lodeta0=1 rsh=482.82876712328766

// l=0.15 w=65.7 nf=31 -> bin nlowvt_model.8  rsh=485.5411 delvto=0 (folded into vth0)
model nlowvt_model__w65p7nf31 bsim4 \
    type=n version=4.50 binunit=2 mobmod=0 \
    capmod=2 rdsmod=0 igcmod=0 igbmod=0 \
    rbodymod=1 trnqsmod=0 acnqsmod=0 fnoimod=1 \
    tnoimod=1 diomod=1 tempmod=0 permod=1 \
    geomod=0 rgatemod=0 epsrox=3.9 toxe=4.148E-9 \
    toxm=4.148E-9 dtox=0 xj=1.5E-7 ndep=1.7E17 \
    ngate=9.999999999999999E22 nsd=1E20 rshg=0.1 phin=0 \
    wint=2.6e-08 wl=0 wln=1 ww=0 \
    wwn=1 wwl=0 lint=1.2025e-08 ll=0 \
    lln=1 lw=0 lwn=1 lwl=0 \
    llc=0 lwc=0 lwlc=0 wlc=0 \
    wwc=0 wwlc=0 dwg=-1.33E-8 dwb=-1.08E-8 \
    xl=0 xw=0 dmcg=0 dmdg=0 \
    dmcgt=0 xgw=0 xgl=0 ngcon=1 \
    vth0=0.249959346666667 lvth0=-1.985141612666671E-9 vfb=0 k1=1.011211866666667 \
    lk1=-4.876429660666666E-8 k2=-0.21737859252 lk2=1.7355223637994E-8 k3=1.65 \
    k3b=1.6 w0=1E-7 lpe0=2.3802E-7 lpeb=-4.9152E-8 \
    vbm=-3 dvtp0=0 dvtp1=0 dvt0=0.07665 \
    dvt1=0.1252 dvt2=-0.05637 dvt0w=0 dvt1w=5.3E6 \
    dvt2w=-0.032 vfbsdoff=0 u0=0.01421071555 lu0=2.166698264775001E-10 \
    ua=-3.496851672833332E-9 lua=1.729222681883582E-16 ub=4.57941585E-18 lub=-2.719028563075E-25 \
    uc=1.863698448333334E-10 luc=-2.261771620175834E-17 ud=0 up=0 \
    lp=1 eu=1.67 vsat=1.819855189500001E5 lvsat=-1.786254255252507E-3 \
    a0=0 ags=1.005218833333333 lags=3.096873294166675E-8 b0=0 \
    b1=0 keta=0.1569286063 lketa=-4.276737497598501E-8 a1=0 \
    a2=0.38689047 rdsw=103.65 rdswmin=0 rdw=0 \
    rdwmin=0 rsw=0 rswmin=0 prwb=0 \
    prwg=0 wr=1 voff=-0.11934831869 lvoff=5.296050099455504E-9 \
    voffl=0 minv=0 nfactor=0.723459400166666 lnfactor=3.583940752490084E-7 \
    eta0=0.067637351756667 leta0=1.529144370447834E-9 etab=-0.077077273825 letab=9.70788263825875E-9 \
    dsub=0.58180516425 ldsub=-4.053136043728748E-8 cit=5E-6 cdsc=3.8556E-37 \
    cdscb=-1.1484E-4 cdscd=4.7984E-6 pclm=0.086824416666667 lpclm=9.59179572083335E-9 \
    pdiblc1=3.583688213883334 lpdiblc1=-4.029261769551058E-7 pdiblc2=0.064735802833333 lpdiblc2=-7.957785851858334E-9 \
    pdiblcb=0 drout=3.4946 pscbe1=4.5E8 pscbe2=1E-8 \
    pvag=0 delta=0.01 fprout=0 pdits=1.4427E-15 \
    pditsl=0 pditsd=0 lambda=0 vtl=0 \
    lc=0 xn=0 alpha0=1.687407635666667E-3 lalpha0=-1.627859334572167E-10 \
    alpha1=0 beta0=31.24083182666667 lbeta0=-3.496153888186668E-7 aigbacc=1 \
    bigbacc=0 cigbacc=0 nigbacc=1 aigbinv=0.35 \
    bigbinv=0.03 cigbinv=6E-3 eigbinv=1.1 nigbinv=3 \
    aigc=0.43 bigc=0.054 cigc=0.075 aigsd=0.43 \
    bigsd=0.054 cigsd=0.075 dlcig=0 nigc=1 \
    poxedge=1 pigcd=1 ntox=1 toxref=4.148E-9 \
    agidl=0 bgidl=2.3E9 cgidl=0.5 egidl=0.8 \
    noia=9E41 noib=1E27 noic=8E11 em=4.1E7 \
    af=1 ef=1.2 kf=0 lintnoi=-3E-7 \
    tnoia=2.5E7 tnoib=9.9E6 ntnoi=1 rnoia=0.912 \
    rnoib=0.26 xpart=0 cgso=2.392894381e-10 cgdo=2.392894381e-10 \
    cgbo=1e-14 ckappas=0.6 cf=1E-14 clc=1E-7 \
    cle=0.6 dlc=1.21071E-8 dwc=2.6E-8 vfbcv=-1 \
    noff=3.8661 voffcv=-0.16994 acde=0.38008 moin=23.81 \
    cgsl=2.310725e-11 cgdl=2.310725e-11 ijthsrev=0.1 ijthsfwd=0.1 \
    xjbvs=1 bvs=11.9 jss=2.75E-3 jsws=6E-10 \
    cjs=0.00121 mjs=0.42197 mjsws=1E-3 cjsws=3.230311424e-11 \
    cjswgs=1.795291232e-10 mjswgs=0.8 pbs=0.7477 pbsws=0.1 \
    pbswgs=0.79644 xrcrg1=12 xrcrg2=1 rbpb=50 \
    rbpd=50 rbps=50 rbdb=50 rbsb=50 \
    gbmin=1E-12 tnom=30 ute=-2.841387833333333 lute=1.462012276083332E-7 \
    kt1=-0.295119316666667 lkt1=-2.874265065833337E-9 kt1l=0 kt2=0.02122778 \
    lkt2=-5.743292291000001E-9 ua1=-2.42902207E-9 lua1=3.816539507165E-16 ub1=2.4443796E-18 \
    lub1=-4.0006627012E-25 uc1=5.2148775E-12 luc1=-5.195283211249999E-19 at=6.394335E4 \
    lat=2.4945216175E-3 prt=0 njs=1.2928 xtis=2 \
    tpb=1.2287E-3 tpbsw=0 tpbswg=0 tcj=7.92E-4 \
    tcjsw=1E-5 tcjswg=0 tvoff=0 tvfbsdoff=0 \
    saref=1.1E-6 sbref=1.1E-6 wlod=0 ku0=-2.7E-8 \
    kvsat=0.2 kvth0=7.9E-9 tku0=0 llodku0=0 \
    wlodku0=1 llodvth=0 wlodvth=1 lku0=0 \
    wku0=0 pku0=0 lkvth0=0 wkvth0=3E-7 \
    pkvth0=0 stk2=0 lodk2=1 steta0=0 \
    lodeta0=1 rsh=485.54109589041093

// l=0.15 w=65.7 nf=33 -> bin nlowvt_model.8  rsh=488.2534 delvto=0 (folded into vth0)
model nlowvt_model__w65p7nf33 bsim4 \
    type=n version=4.50 binunit=2 mobmod=0 \
    capmod=2 rdsmod=0 igcmod=0 igbmod=0 \
    rbodymod=1 trnqsmod=0 acnqsmod=0 fnoimod=1 \
    tnoimod=1 diomod=1 tempmod=0 permod=1 \
    geomod=0 rgatemod=0 epsrox=3.9 toxe=4.148E-9 \
    toxm=4.148E-9 dtox=0 xj=1.5E-7 ndep=1.7E17 \
    ngate=9.999999999999999E22 nsd=1E20 rshg=0.1 phin=0 \
    wint=2.6e-08 wl=0 wln=1 ww=0 \
    wwn=1 wwl=0 lint=1.2025e-08 ll=0 \
    lln=1 lw=0 lwn=1 lwl=0 \
    llc=0 lwc=0 lwlc=0 wlc=0 \
    wwc=0 wwlc=0 dwg=-1.33E-8 dwb=-1.08E-8 \
    xl=0 xw=0 dmcg=0 dmdg=0 \
    dmcgt=0 xgw=0 xgl=0 ngcon=1 \
    vth0=0.249959346666667 lvth0=-1.985141612666671E-9 vfb=0 k1=1.011211866666667 \
    lk1=-4.876429660666666E-8 k2=-0.21737859252 lk2=1.7355223637994E-8 k3=1.65 \
    k3b=1.6 w0=1E-7 lpe0=2.3802E-7 lpeb=-4.9152E-8 \
    vbm=-3 dvtp0=0 dvtp1=0 dvt0=0.07665 \
    dvt1=0.1252 dvt2=-0.05637 dvt0w=0 dvt1w=5.3E6 \
    dvt2w=-0.032 vfbsdoff=0 u0=0.01421071555 lu0=2.166698264775001E-10 \
    ua=-3.496851672833332E-9 lua=1.729222681883582E-16 ub=4.57941585E-18 lub=-2.719028563075E-25 \
    uc=1.863698448333334E-10 luc=-2.261771620175834E-17 ud=0 up=0 \
    lp=1 eu=1.67 vsat=1.819855189500001E5 lvsat=-1.786254255252507E-3 \
    a0=0 ags=1.005218833333333 lags=3.096873294166675E-8 b0=0 \
    b1=0 keta=0.1569286063 lketa=-4.276737497598501E-8 a1=0 \
    a2=0.38689047 rdsw=103.65 rdswmin=0 rdw=0 \
    rdwmin=0 rsw=0 rswmin=0 prwb=0 \
    prwg=0 wr=1 voff=-0.11934831869 lvoff=5.296050099455504E-9 \
    voffl=0 minv=0 nfactor=0.723459400166666 lnfactor=3.583940752490084E-7 \
    eta0=0.067637351756667 leta0=1.529144370447834E-9 etab=-0.077077273825 letab=9.70788263825875E-9 \
    dsub=0.58180516425 ldsub=-4.053136043728748E-8 cit=5E-6 cdsc=3.8556E-37 \
    cdscb=-1.1484E-4 cdscd=4.7984E-6 pclm=0.086824416666667 lpclm=9.59179572083335E-9 \
    pdiblc1=3.583688213883334 lpdiblc1=-4.029261769551058E-7 pdiblc2=0.064735802833333 lpdiblc2=-7.957785851858334E-9 \
    pdiblcb=0 drout=3.4946 pscbe1=4.5E8 pscbe2=1E-8 \
    pvag=0 delta=0.01 fprout=0 pdits=1.4427E-15 \
    pditsl=0 pditsd=0 lambda=0 vtl=0 \
    lc=0 xn=0 alpha0=1.687407635666667E-3 lalpha0=-1.627859334572167E-10 \
    alpha1=0 beta0=31.24083182666667 lbeta0=-3.496153888186668E-7 aigbacc=1 \
    bigbacc=0 cigbacc=0 nigbacc=1 aigbinv=0.35 \
    bigbinv=0.03 cigbinv=6E-3 eigbinv=1.1 nigbinv=3 \
    aigc=0.43 bigc=0.054 cigc=0.075 aigsd=0.43 \
    bigsd=0.054 cigsd=0.075 dlcig=0 nigc=1 \
    poxedge=1 pigcd=1 ntox=1 toxref=4.148E-9 \
    agidl=0 bgidl=2.3E9 cgidl=0.5 egidl=0.8 \
    noia=9E41 noib=1E27 noic=8E11 em=4.1E7 \
    af=1 ef=1.2 kf=0 lintnoi=-3E-7 \
    tnoia=2.5E7 tnoib=9.9E6 ntnoi=1 rnoia=0.912 \
    rnoib=0.26 xpart=0 cgso=2.392894381e-10 cgdo=2.392894381e-10 \
    cgbo=1e-14 ckappas=0.6 cf=1E-14 clc=1E-7 \
    cle=0.6 dlc=1.21071E-8 dwc=2.6E-8 vfbcv=-1 \
    noff=3.8661 voffcv=-0.16994 acde=0.38008 moin=23.81 \
    cgsl=2.310725e-11 cgdl=2.310725e-11 ijthsrev=0.1 ijthsfwd=0.1 \
    xjbvs=1 bvs=11.9 jss=2.75E-3 jsws=6E-10 \
    cjs=0.00121 mjs=0.42197 mjsws=1E-3 cjsws=3.230311424e-11 \
    cjswgs=1.795291232e-10 mjswgs=0.8 pbs=0.7477 pbsws=0.1 \
    pbswgs=0.79644 xrcrg1=12 xrcrg2=1 rbpb=50 \
    rbpd=50 rbps=50 rbdb=50 rbsb=50 \
    gbmin=1E-12 tnom=30 ute=-2.841387833333333 lute=1.462012276083332E-7 \
    kt1=-0.295119316666667 lkt1=-2.874265065833337E-9 kt1l=0 kt2=0.02122778 \
    lkt2=-5.743292291000001E-9 ua1=-2.42902207E-9 lua1=3.816539507165E-16 ub1=2.4443796E-18 \
    lub1=-4.0006627012E-25 uc1=5.2148775E-12 luc1=-5.195283211249999E-19 at=6.394335E4 \
    lat=2.4945216175E-3 prt=0 njs=1.2928 xtis=2 \
    tpb=1.2287E-3 tpbsw=0 tpbswg=0 tcj=7.92E-4 \
    tcjsw=1E-5 tcjswg=0 tvoff=0 tvfbsdoff=0 \
    saref=1.1E-6 sbref=1.1E-6 wlod=0 ku0=-2.7E-8 \
    kvsat=0.2 kvth0=7.9E-9 tku0=0 llodku0=0 \
    wlodku0=1 llodvth=0 wlodvth=1 lku0=0 \
    wku0=0 pku0=0 lkvth0=0 wkvth0=3E-7 \
    pkvth0=0 stk2=0 lodk2=1 steta0=0 \
    lodeta0=1 rsh=488.25342465753425

// l=0.15 w=65.7 nf=35 -> bin nlowvt_model.8  rsh=490.9658 delvto=0 (folded into vth0)
model nlowvt_model__w65p7nf35 bsim4 \
    type=n version=4.50 binunit=2 mobmod=0 \
    capmod=2 rdsmod=0 igcmod=0 igbmod=0 \
    rbodymod=1 trnqsmod=0 acnqsmod=0 fnoimod=1 \
    tnoimod=1 diomod=1 tempmod=0 permod=1 \
    geomod=0 rgatemod=0 epsrox=3.9 toxe=4.148E-9 \
    toxm=4.148E-9 dtox=0 xj=1.5E-7 ndep=1.7E17 \
    ngate=9.999999999999999E22 nsd=1E20 rshg=0.1 phin=0 \
    wint=2.6e-08 wl=0 wln=1 ww=0 \
    wwn=1 wwl=0 lint=1.2025e-08 ll=0 \
    lln=1 lw=0 lwn=1 lwl=0 \
    llc=0 lwc=0 lwlc=0 wlc=0 \
    wwc=0 wwlc=0 dwg=-1.33E-8 dwb=-1.08E-8 \
    xl=0 xw=0 dmcg=0 dmdg=0 \
    dmcgt=0 xgw=0 xgl=0 ngcon=1 \
    vth0=0.249959346666667 lvth0=-1.985141612666671E-9 vfb=0 k1=1.011211866666667 \
    lk1=-4.876429660666666E-8 k2=-0.21737859252 lk2=1.7355223637994E-8 k3=1.65 \
    k3b=1.6 w0=1E-7 lpe0=2.3802E-7 lpeb=-4.9152E-8 \
    vbm=-3 dvtp0=0 dvtp1=0 dvt0=0.07665 \
    dvt1=0.1252 dvt2=-0.05637 dvt0w=0 dvt1w=5.3E6 \
    dvt2w=-0.032 vfbsdoff=0 u0=0.01421071555 lu0=2.166698264775001E-10 \
    ua=-3.496851672833332E-9 lua=1.729222681883582E-16 ub=4.57941585E-18 lub=-2.719028563075E-25 \
    uc=1.863698448333334E-10 luc=-2.261771620175834E-17 ud=0 up=0 \
    lp=1 eu=1.67 vsat=1.819855189500001E5 lvsat=-1.786254255252507E-3 \
    a0=0 ags=1.005218833333333 lags=3.096873294166675E-8 b0=0 \
    b1=0 keta=0.1569286063 lketa=-4.276737497598501E-8 a1=0 \
    a2=0.38689047 rdsw=103.65 rdswmin=0 rdw=0 \
    rdwmin=0 rsw=0 rswmin=0 prwb=0 \
    prwg=0 wr=1 voff=-0.11934831869 lvoff=5.296050099455504E-9 \
    voffl=0 minv=0 nfactor=0.723459400166666 lnfactor=3.583940752490084E-7 \
    eta0=0.067637351756667 leta0=1.529144370447834E-9 etab=-0.077077273825 letab=9.70788263825875E-9 \
    dsub=0.58180516425 ldsub=-4.053136043728748E-8 cit=5E-6 cdsc=3.8556E-37 \
    cdscb=-1.1484E-4 cdscd=4.7984E-6 pclm=0.086824416666667 lpclm=9.59179572083335E-9 \
    pdiblc1=3.583688213883334 lpdiblc1=-4.029261769551058E-7 pdiblc2=0.064735802833333 lpdiblc2=-7.957785851858334E-9 \
    pdiblcb=0 drout=3.4946 pscbe1=4.5E8 pscbe2=1E-8 \
    pvag=0 delta=0.01 fprout=0 pdits=1.4427E-15 \
    pditsl=0 pditsd=0 lambda=0 vtl=0 \
    lc=0 xn=0 alpha0=1.687407635666667E-3 lalpha0=-1.627859334572167E-10 \
    alpha1=0 beta0=31.24083182666667 lbeta0=-3.496153888186668E-7 aigbacc=1 \
    bigbacc=0 cigbacc=0 nigbacc=1 aigbinv=0.35 \
    bigbinv=0.03 cigbinv=6E-3 eigbinv=1.1 nigbinv=3 \
    aigc=0.43 bigc=0.054 cigc=0.075 aigsd=0.43 \
    bigsd=0.054 cigsd=0.075 dlcig=0 nigc=1 \
    poxedge=1 pigcd=1 ntox=1 toxref=4.148E-9 \
    agidl=0 bgidl=2.3E9 cgidl=0.5 egidl=0.8 \
    noia=9E41 noib=1E27 noic=8E11 em=4.1E7 \
    af=1 ef=1.2 kf=0 lintnoi=-3E-7 \
    tnoia=2.5E7 tnoib=9.9E6 ntnoi=1 rnoia=0.912 \
    rnoib=0.26 xpart=0 cgso=2.392894381e-10 cgdo=2.392894381e-10 \
    cgbo=1e-14 ckappas=0.6 cf=1E-14 clc=1E-7 \
    cle=0.6 dlc=1.21071E-8 dwc=2.6E-8 vfbcv=-1 \
    noff=3.8661 voffcv=-0.16994 acde=0.38008 moin=23.81 \
    cgsl=2.310725e-11 cgdl=2.310725e-11 ijthsrev=0.1 ijthsfwd=0.1 \
    xjbvs=1 bvs=11.9 jss=2.75E-3 jsws=6E-10 \
    cjs=0.00121 mjs=0.42197 mjsws=1E-3 cjsws=3.230311424e-11 \
    cjswgs=1.795291232e-10 mjswgs=0.8 pbs=0.7477 pbsws=0.1 \
    pbswgs=0.79644 xrcrg1=12 xrcrg2=1 rbpb=50 \
    rbpd=50 rbps=50 rbdb=50 rbsb=50 \
    gbmin=1E-12 tnom=30 ute=-2.841387833333333 lute=1.462012276083332E-7 \
    kt1=-0.295119316666667 lkt1=-2.874265065833337E-9 kt1l=0 kt2=0.02122778 \
    lkt2=-5.743292291000001E-9 ua1=-2.42902207E-9 lua1=3.816539507165E-16 ub1=2.4443796E-18 \
    lub1=-4.0006627012E-25 uc1=5.2148775E-12 luc1=-5.195283211249999E-19 at=6.394335E4 \
    lat=2.4945216175E-3 prt=0 njs=1.2928 xtis=2 \
    tpb=1.2287E-3 tpbsw=0 tpbswg=0 tcj=7.92E-4 \
    tcjsw=1E-5 tcjswg=0 tvoff=0 tvfbsdoff=0 \
    saref=1.1E-6 sbref=1.1E-6 wlod=0 ku0=-2.7E-8 \
    kvsat=0.2 kvth0=7.9E-9 tku0=0 llodku0=0 \
    wlodku0=1 llodvth=0 wlodvth=1 lku0=0 \
    wku0=0 pku0=0 lkvth0=0 wkvth0=3E-7 \
    pkvth0=0 stk2=0 lodk2=1 steta0=0 \
    lodeta0=1 rsh=490.9657534246575

// l=0.15 w=69.7 nf=27 -> bin nlowvt_model.8  rsh=478.0151 delvto=0 (folded into vth0)
model nlowvt_model__w69p7nf27 bsim4 \
    type=n version=4.50 binunit=2 mobmod=0 \
    capmod=2 rdsmod=0 igcmod=0 igbmod=0 \
    rbodymod=1 trnqsmod=0 acnqsmod=0 fnoimod=1 \
    tnoimod=1 diomod=1 tempmod=0 permod=1 \
    geomod=0 rgatemod=0 epsrox=3.9 toxe=4.148E-9 \
    toxm=4.148E-9 dtox=0 xj=1.5E-7 ndep=1.7E17 \
    ngate=9.999999999999999E22 nsd=1E20 rshg=0.1 phin=0 \
    wint=2.6e-08 wl=0 wln=1 ww=0 \
    wwn=1 wwl=0 lint=1.2025e-08 ll=0 \
    lln=1 lw=0 lwn=1 lwl=0 \
    llc=0 lwc=0 lwlc=0 wlc=0 \
    wwc=0 wwlc=0 dwg=-1.33E-8 dwb=-1.08E-8 \
    xl=0 xw=0 dmcg=0 dmdg=0 \
    dmcgt=0 xgw=0 xgl=0 ngcon=1 \
    vth0=0.249959346666667 lvth0=-1.985141612666671E-9 vfb=0 k1=1.011211866666667 \
    lk1=-4.876429660666666E-8 k2=-0.21737859252 lk2=1.7355223637994E-8 k3=1.65 \
    k3b=1.6 w0=1E-7 lpe0=2.3802E-7 lpeb=-4.9152E-8 \
    vbm=-3 dvtp0=0 dvtp1=0 dvt0=0.07665 \
    dvt1=0.1252 dvt2=-0.05637 dvt0w=0 dvt1w=5.3E6 \
    dvt2w=-0.032 vfbsdoff=0 u0=0.01421071555 lu0=2.166698264775001E-10 \
    ua=-3.496851672833332E-9 lua=1.729222681883582E-16 ub=4.57941585E-18 lub=-2.719028563075E-25 \
    uc=1.863698448333334E-10 luc=-2.261771620175834E-17 ud=0 up=0 \
    lp=1 eu=1.67 vsat=1.819855189500001E5 lvsat=-1.786254255252507E-3 \
    a0=0 ags=1.005218833333333 lags=3.096873294166675E-8 b0=0 \
    b1=0 keta=0.1569286063 lketa=-4.276737497598501E-8 a1=0 \
    a2=0.38689047 rdsw=103.65 rdswmin=0 rdw=0 \
    rdwmin=0 rsw=0 rswmin=0 prwb=0 \
    prwg=0 wr=1 voff=-0.11934831869 lvoff=5.296050099455504E-9 \
    voffl=0 minv=0 nfactor=0.723459400166666 lnfactor=3.583940752490084E-7 \
    eta0=0.067637351756667 leta0=1.529144370447834E-9 etab=-0.077077273825 letab=9.70788263825875E-9 \
    dsub=0.58180516425 ldsub=-4.053136043728748E-8 cit=5E-6 cdsc=3.8556E-37 \
    cdscb=-1.1484E-4 cdscd=4.7984E-6 pclm=0.086824416666667 lpclm=9.59179572083335E-9 \
    pdiblc1=3.583688213883334 lpdiblc1=-4.029261769551058E-7 pdiblc2=0.064735802833333 lpdiblc2=-7.957785851858334E-9 \
    pdiblcb=0 drout=3.4946 pscbe1=4.5E8 pscbe2=1E-8 \
    pvag=0 delta=0.01 fprout=0 pdits=1.4427E-15 \
    pditsl=0 pditsd=0 lambda=0 vtl=0 \
    lc=0 xn=0 alpha0=1.687407635666667E-3 lalpha0=-1.627859334572167E-10 \
    alpha1=0 beta0=31.24083182666667 lbeta0=-3.496153888186668E-7 aigbacc=1 \
    bigbacc=0 cigbacc=0 nigbacc=1 aigbinv=0.35 \
    bigbinv=0.03 cigbinv=6E-3 eigbinv=1.1 nigbinv=3 \
    aigc=0.43 bigc=0.054 cigc=0.075 aigsd=0.43 \
    bigsd=0.054 cigsd=0.075 dlcig=0 nigc=1 \
    poxedge=1 pigcd=1 ntox=1 toxref=4.148E-9 \
    agidl=0 bgidl=2.3E9 cgidl=0.5 egidl=0.8 \
    noia=9E41 noib=1E27 noic=8E11 em=4.1E7 \
    af=1 ef=1.2 kf=0 lintnoi=-3E-7 \
    tnoia=2.5E7 tnoib=9.9E6 ntnoi=1 rnoia=0.912 \
    rnoib=0.26 xpart=0 cgso=2.392894381e-10 cgdo=2.392894381e-10 \
    cgbo=1e-14 ckappas=0.6 cf=1E-14 clc=1E-7 \
    cle=0.6 dlc=1.21071E-8 dwc=2.6E-8 vfbcv=-1 \
    noff=3.8661 voffcv=-0.16994 acde=0.38008 moin=23.81 \
    cgsl=2.310725e-11 cgdl=2.310725e-11 ijthsrev=0.1 ijthsfwd=0.1 \
    xjbvs=1 bvs=11.9 jss=2.75E-3 jsws=6E-10 \
    cjs=0.00121 mjs=0.42197 mjsws=1E-3 cjsws=3.230311424e-11 \
    cjswgs=1.795291232e-10 mjswgs=0.8 pbs=0.7477 pbsws=0.1 \
    pbswgs=0.79644 xrcrg1=12 xrcrg2=1 rbpb=50 \
    rbpd=50 rbps=50 rbdb=50 rbsb=50 \
    gbmin=1E-12 tnom=30 ute=-2.841387833333333 lute=1.462012276083332E-7 \
    kt1=-0.295119316666667 lkt1=-2.874265065833337E-9 kt1l=0 kt2=0.02122778 \
    lkt2=-5.743292291000001E-9 ua1=-2.42902207E-9 lua1=3.816539507165E-16 ub1=2.4443796E-18 \
    lub1=-4.0006627012E-25 uc1=5.2148775E-12 luc1=-5.195283211249999E-19 at=6.394335E4 \
    lat=2.4945216175E-3 prt=0 njs=1.2928 xtis=2 \
    tpb=1.2287E-3 tpbsw=0 tpbswg=0 tcj=7.92E-4 \
    tcjsw=1E-5 tcjswg=0 tvoff=0 tvfbsdoff=0 \
    saref=1.1E-6 sbref=1.1E-6 wlod=0 ku0=-2.7E-8 \
    kvsat=0.2 kvth0=7.9E-9 tku0=0 llodku0=0 \
    wlodku0=1 llodvth=0 wlodvth=1 lku0=0 \
    wku0=0 pku0=0 lkvth0=0 wkvth0=3E-7 \
    pkvth0=0 stk2=0 lodk2=1 steta0=0 \
    lodeta0=1 rsh=478.0150645624103

// l=0.15 w=69.7 nf=29 -> bin nlowvt_model.8  rsh=480.5717 delvto=0 (folded into vth0)
model nlowvt_model__w69p7nf29 bsim4 \
    type=n version=4.50 binunit=2 mobmod=0 \
    capmod=2 rdsmod=0 igcmod=0 igbmod=0 \
    rbodymod=1 trnqsmod=0 acnqsmod=0 fnoimod=1 \
    tnoimod=1 diomod=1 tempmod=0 permod=1 \
    geomod=0 rgatemod=0 epsrox=3.9 toxe=4.148E-9 \
    toxm=4.148E-9 dtox=0 xj=1.5E-7 ndep=1.7E17 \
    ngate=9.999999999999999E22 nsd=1E20 rshg=0.1 phin=0 \
    wint=2.6e-08 wl=0 wln=1 ww=0 \
    wwn=1 wwl=0 lint=1.2025e-08 ll=0 \
    lln=1 lw=0 lwn=1 lwl=0 \
    llc=0 lwc=0 lwlc=0 wlc=0 \
    wwc=0 wwlc=0 dwg=-1.33E-8 dwb=-1.08E-8 \
    xl=0 xw=0 dmcg=0 dmdg=0 \
    dmcgt=0 xgw=0 xgl=0 ngcon=1 \
    vth0=0.249959346666667 lvth0=-1.985141612666671E-9 vfb=0 k1=1.011211866666667 \
    lk1=-4.876429660666666E-8 k2=-0.21737859252 lk2=1.7355223637994E-8 k3=1.65 \
    k3b=1.6 w0=1E-7 lpe0=2.3802E-7 lpeb=-4.9152E-8 \
    vbm=-3 dvtp0=0 dvtp1=0 dvt0=0.07665 \
    dvt1=0.1252 dvt2=-0.05637 dvt0w=0 dvt1w=5.3E6 \
    dvt2w=-0.032 vfbsdoff=0 u0=0.01421071555 lu0=2.166698264775001E-10 \
    ua=-3.496851672833332E-9 lua=1.729222681883582E-16 ub=4.57941585E-18 lub=-2.719028563075E-25 \
    uc=1.863698448333334E-10 luc=-2.261771620175834E-17 ud=0 up=0 \
    lp=1 eu=1.67 vsat=1.819855189500001E5 lvsat=-1.786254255252507E-3 \
    a0=0 ags=1.005218833333333 lags=3.096873294166675E-8 b0=0 \
    b1=0 keta=0.1569286063 lketa=-4.276737497598501E-8 a1=0 \
    a2=0.38689047 rdsw=103.65 rdswmin=0 rdw=0 \
    rdwmin=0 rsw=0 rswmin=0 prwb=0 \
    prwg=0 wr=1 voff=-0.11934831869 lvoff=5.296050099455504E-9 \
    voffl=0 minv=0 nfactor=0.723459400166666 lnfactor=3.583940752490084E-7 \
    eta0=0.067637351756667 leta0=1.529144370447834E-9 etab=-0.077077273825 letab=9.70788263825875E-9 \
    dsub=0.58180516425 ldsub=-4.053136043728748E-8 cit=5E-6 cdsc=3.8556E-37 \
    cdscb=-1.1484E-4 cdscd=4.7984E-6 pclm=0.086824416666667 lpclm=9.59179572083335E-9 \
    pdiblc1=3.583688213883334 lpdiblc1=-4.029261769551058E-7 pdiblc2=0.064735802833333 lpdiblc2=-7.957785851858334E-9 \
    pdiblcb=0 drout=3.4946 pscbe1=4.5E8 pscbe2=1E-8 \
    pvag=0 delta=0.01 fprout=0 pdits=1.4427E-15 \
    pditsl=0 pditsd=0 lambda=0 vtl=0 \
    lc=0 xn=0 alpha0=1.687407635666667E-3 lalpha0=-1.627859334572167E-10 \
    alpha1=0 beta0=31.24083182666667 lbeta0=-3.496153888186668E-7 aigbacc=1 \
    bigbacc=0 cigbacc=0 nigbacc=1 aigbinv=0.35 \
    bigbinv=0.03 cigbinv=6E-3 eigbinv=1.1 nigbinv=3 \
    aigc=0.43 bigc=0.054 cigc=0.075 aigsd=0.43 \
    bigsd=0.054 cigsd=0.075 dlcig=0 nigc=1 \
    poxedge=1 pigcd=1 ntox=1 toxref=4.148E-9 \
    agidl=0 bgidl=2.3E9 cgidl=0.5 egidl=0.8 \
    noia=9E41 noib=1E27 noic=8E11 em=4.1E7 \
    af=1 ef=1.2 kf=0 lintnoi=-3E-7 \
    tnoia=2.5E7 tnoib=9.9E6 ntnoi=1 rnoia=0.912 \
    rnoib=0.26 xpart=0 cgso=2.392894381e-10 cgdo=2.392894381e-10 \
    cgbo=1e-14 ckappas=0.6 cf=1E-14 clc=1E-7 \
    cle=0.6 dlc=1.21071E-8 dwc=2.6E-8 vfbcv=-1 \
    noff=3.8661 voffcv=-0.16994 acde=0.38008 moin=23.81 \
    cgsl=2.310725e-11 cgdl=2.310725e-11 ijthsrev=0.1 ijthsfwd=0.1 \
    xjbvs=1 bvs=11.9 jss=2.75E-3 jsws=6E-10 \
    cjs=0.00121 mjs=0.42197 mjsws=1E-3 cjsws=3.230311424e-11 \
    cjswgs=1.795291232e-10 mjswgs=0.8 pbs=0.7477 pbsws=0.1 \
    pbswgs=0.79644 xrcrg1=12 xrcrg2=1 rbpb=50 \
    rbpd=50 rbps=50 rbdb=50 rbsb=50 \
    gbmin=1E-12 tnom=30 ute=-2.841387833333333 lute=1.462012276083332E-7 \
    kt1=-0.295119316666667 lkt1=-2.874265065833337E-9 kt1l=0 kt2=0.02122778 \
    lkt2=-5.743292291000001E-9 ua1=-2.42902207E-9 lua1=3.816539507165E-16 ub1=2.4443796E-18 \
    lub1=-4.0006627012E-25 uc1=5.2148775E-12 luc1=-5.195283211249999E-19 at=6.394335E4 \
    lat=2.4945216175E-3 prt=0 njs=1.2928 xtis=2 \
    tpb=1.2287E-3 tpbsw=0 tpbswg=0 tcj=7.92E-4 \
    tcjsw=1E-5 tcjswg=0 tvoff=0 tvfbsdoff=0 \
    saref=1.1E-6 sbref=1.1E-6 wlod=0 ku0=-2.7E-8 \
    kvsat=0.2 kvth0=7.9E-9 tku0=0 llodku0=0 \
    wlodku0=1 llodvth=0 wlodvth=1 lku0=0 \
    wku0=0 pku0=0 lkvth0=0 wkvth0=3E-7 \
    pkvth0=0 stk2=0 lodk2=1 steta0=0 \
    lodeta0=1 rsh=480.57173601147775

// l=0.15 w=69.7 nf=31 -> bin nlowvt_model.8  rsh=483.1284 delvto=0 (folded into vth0)
model nlowvt_model__w69p7nf31 bsim4 \
    type=n version=4.50 binunit=2 mobmod=0 \
    capmod=2 rdsmod=0 igcmod=0 igbmod=0 \
    rbodymod=1 trnqsmod=0 acnqsmod=0 fnoimod=1 \
    tnoimod=1 diomod=1 tempmod=0 permod=1 \
    geomod=0 rgatemod=0 epsrox=3.9 toxe=4.148E-9 \
    toxm=4.148E-9 dtox=0 xj=1.5E-7 ndep=1.7E17 \
    ngate=9.999999999999999E22 nsd=1E20 rshg=0.1 phin=0 \
    wint=2.6e-08 wl=0 wln=1 ww=0 \
    wwn=1 wwl=0 lint=1.2025e-08 ll=0 \
    lln=1 lw=0 lwn=1 lwl=0 \
    llc=0 lwc=0 lwlc=0 wlc=0 \
    wwc=0 wwlc=0 dwg=-1.33E-8 dwb=-1.08E-8 \
    xl=0 xw=0 dmcg=0 dmdg=0 \
    dmcgt=0 xgw=0 xgl=0 ngcon=1 \
    vth0=0.249959346666667 lvth0=-1.985141612666671E-9 vfb=0 k1=1.011211866666667 \
    lk1=-4.876429660666666E-8 k2=-0.21737859252 lk2=1.7355223637994E-8 k3=1.65 \
    k3b=1.6 w0=1E-7 lpe0=2.3802E-7 lpeb=-4.9152E-8 \
    vbm=-3 dvtp0=0 dvtp1=0 dvt0=0.07665 \
    dvt1=0.1252 dvt2=-0.05637 dvt0w=0 dvt1w=5.3E6 \
    dvt2w=-0.032 vfbsdoff=0 u0=0.01421071555 lu0=2.166698264775001E-10 \
    ua=-3.496851672833332E-9 lua=1.729222681883582E-16 ub=4.57941585E-18 lub=-2.719028563075E-25 \
    uc=1.863698448333334E-10 luc=-2.261771620175834E-17 ud=0 up=0 \
    lp=1 eu=1.67 vsat=1.819855189500001E5 lvsat=-1.786254255252507E-3 \
    a0=0 ags=1.005218833333333 lags=3.096873294166675E-8 b0=0 \
    b1=0 keta=0.1569286063 lketa=-4.276737497598501E-8 a1=0 \
    a2=0.38689047 rdsw=103.65 rdswmin=0 rdw=0 \
    rdwmin=0 rsw=0 rswmin=0 prwb=0 \
    prwg=0 wr=1 voff=-0.11934831869 lvoff=5.296050099455504E-9 \
    voffl=0 minv=0 nfactor=0.723459400166666 lnfactor=3.583940752490084E-7 \
    eta0=0.067637351756667 leta0=1.529144370447834E-9 etab=-0.077077273825 letab=9.70788263825875E-9 \
    dsub=0.58180516425 ldsub=-4.053136043728748E-8 cit=5E-6 cdsc=3.8556E-37 \
    cdscb=-1.1484E-4 cdscd=4.7984E-6 pclm=0.086824416666667 lpclm=9.59179572083335E-9 \
    pdiblc1=3.583688213883334 lpdiblc1=-4.029261769551058E-7 pdiblc2=0.064735802833333 lpdiblc2=-7.957785851858334E-9 \
    pdiblcb=0 drout=3.4946 pscbe1=4.5E8 pscbe2=1E-8 \
    pvag=0 delta=0.01 fprout=0 pdits=1.4427E-15 \
    pditsl=0 pditsd=0 lambda=0 vtl=0 \
    lc=0 xn=0 alpha0=1.687407635666667E-3 lalpha0=-1.627859334572167E-10 \
    alpha1=0 beta0=31.24083182666667 lbeta0=-3.496153888186668E-7 aigbacc=1 \
    bigbacc=0 cigbacc=0 nigbacc=1 aigbinv=0.35 \
    bigbinv=0.03 cigbinv=6E-3 eigbinv=1.1 nigbinv=3 \
    aigc=0.43 bigc=0.054 cigc=0.075 aigsd=0.43 \
    bigsd=0.054 cigsd=0.075 dlcig=0 nigc=1 \
    poxedge=1 pigcd=1 ntox=1 toxref=4.148E-9 \
    agidl=0 bgidl=2.3E9 cgidl=0.5 egidl=0.8 \
    noia=9E41 noib=1E27 noic=8E11 em=4.1E7 \
    af=1 ef=1.2 kf=0 lintnoi=-3E-7 \
    tnoia=2.5E7 tnoib=9.9E6 ntnoi=1 rnoia=0.912 \
    rnoib=0.26 xpart=0 cgso=2.392894381e-10 cgdo=2.392894381e-10 \
    cgbo=1e-14 ckappas=0.6 cf=1E-14 clc=1E-7 \
    cle=0.6 dlc=1.21071E-8 dwc=2.6E-8 vfbcv=-1 \
    noff=3.8661 voffcv=-0.16994 acde=0.38008 moin=23.81 \
    cgsl=2.310725e-11 cgdl=2.310725e-11 ijthsrev=0.1 ijthsfwd=0.1 \
    xjbvs=1 bvs=11.9 jss=2.75E-3 jsws=6E-10 \
    cjs=0.00121 mjs=0.42197 mjsws=1E-3 cjsws=3.230311424e-11 \
    cjswgs=1.795291232e-10 mjswgs=0.8 pbs=0.7477 pbsws=0.1 \
    pbswgs=0.79644 xrcrg1=12 xrcrg2=1 rbpb=50 \
    rbpd=50 rbps=50 rbdb=50 rbsb=50 \
    gbmin=1E-12 tnom=30 ute=-2.841387833333333 lute=1.462012276083332E-7 \
    kt1=-0.295119316666667 lkt1=-2.874265065833337E-9 kt1l=0 kt2=0.02122778 \
    lkt2=-5.743292291000001E-9 ua1=-2.42902207E-9 lua1=3.816539507165E-16 ub1=2.4443796E-18 \
    lub1=-4.0006627012E-25 uc1=5.2148775E-12 luc1=-5.195283211249999E-19 at=6.394335E4 \
    lat=2.4945216175E-3 prt=0 njs=1.2928 xtis=2 \
    tpb=1.2287E-3 tpbsw=0 tpbswg=0 tcj=7.92E-4 \
    tcjsw=1E-5 tcjswg=0 tvoff=0 tvfbsdoff=0 \
    saref=1.1E-6 sbref=1.1E-6 wlod=0 ku0=-2.7E-8 \
    kvsat=0.2 kvth0=7.9E-9 tku0=0 llodku0=0 \
    wlodku0=1 llodvth=0 wlodvth=1 lku0=0 \
    wku0=0 pku0=0 lkvth0=0 wkvth0=3E-7 \
    pkvth0=0 stk2=0 lodk2=1 steta0=0 \
    lodeta0=1 rsh=483.1284074605452

// l=0.15 w=69.7 nf=33 -> bin nlowvt_model.8  rsh=485.6851 delvto=0 (folded into vth0)
model nlowvt_model__w69p7nf33 bsim4 \
    type=n version=4.50 binunit=2 mobmod=0 \
    capmod=2 rdsmod=0 igcmod=0 igbmod=0 \
    rbodymod=1 trnqsmod=0 acnqsmod=0 fnoimod=1 \
    tnoimod=1 diomod=1 tempmod=0 permod=1 \
    geomod=0 rgatemod=0 epsrox=3.9 toxe=4.148E-9 \
    toxm=4.148E-9 dtox=0 xj=1.5E-7 ndep=1.7E17 \
    ngate=9.999999999999999E22 nsd=1E20 rshg=0.1 phin=0 \
    wint=2.6e-08 wl=0 wln=1 ww=0 \
    wwn=1 wwl=0 lint=1.2025e-08 ll=0 \
    lln=1 lw=0 lwn=1 lwl=0 \
    llc=0 lwc=0 lwlc=0 wlc=0 \
    wwc=0 wwlc=0 dwg=-1.33E-8 dwb=-1.08E-8 \
    xl=0 xw=0 dmcg=0 dmdg=0 \
    dmcgt=0 xgw=0 xgl=0 ngcon=1 \
    vth0=0.249959346666667 lvth0=-1.985141612666671E-9 vfb=0 k1=1.011211866666667 \
    lk1=-4.876429660666666E-8 k2=-0.21737859252 lk2=1.7355223637994E-8 k3=1.65 \
    k3b=1.6 w0=1E-7 lpe0=2.3802E-7 lpeb=-4.9152E-8 \
    vbm=-3 dvtp0=0 dvtp1=0 dvt0=0.07665 \
    dvt1=0.1252 dvt2=-0.05637 dvt0w=0 dvt1w=5.3E6 \
    dvt2w=-0.032 vfbsdoff=0 u0=0.01421071555 lu0=2.166698264775001E-10 \
    ua=-3.496851672833332E-9 lua=1.729222681883582E-16 ub=4.57941585E-18 lub=-2.719028563075E-25 \
    uc=1.863698448333334E-10 luc=-2.261771620175834E-17 ud=0 up=0 \
    lp=1 eu=1.67 vsat=1.819855189500001E5 lvsat=-1.786254255252507E-3 \
    a0=0 ags=1.005218833333333 lags=3.096873294166675E-8 b0=0 \
    b1=0 keta=0.1569286063 lketa=-4.276737497598501E-8 a1=0 \
    a2=0.38689047 rdsw=103.65 rdswmin=0 rdw=0 \
    rdwmin=0 rsw=0 rswmin=0 prwb=0 \
    prwg=0 wr=1 voff=-0.11934831869 lvoff=5.296050099455504E-9 \
    voffl=0 minv=0 nfactor=0.723459400166666 lnfactor=3.583940752490084E-7 \
    eta0=0.067637351756667 leta0=1.529144370447834E-9 etab=-0.077077273825 letab=9.70788263825875E-9 \
    dsub=0.58180516425 ldsub=-4.053136043728748E-8 cit=5E-6 cdsc=3.8556E-37 \
    cdscb=-1.1484E-4 cdscd=4.7984E-6 pclm=0.086824416666667 lpclm=9.59179572083335E-9 \
    pdiblc1=3.583688213883334 lpdiblc1=-4.029261769551058E-7 pdiblc2=0.064735802833333 lpdiblc2=-7.957785851858334E-9 \
    pdiblcb=0 drout=3.4946 pscbe1=4.5E8 pscbe2=1E-8 \
    pvag=0 delta=0.01 fprout=0 pdits=1.4427E-15 \
    pditsl=0 pditsd=0 lambda=0 vtl=0 \
    lc=0 xn=0 alpha0=1.687407635666667E-3 lalpha0=-1.627859334572167E-10 \
    alpha1=0 beta0=31.24083182666667 lbeta0=-3.496153888186668E-7 aigbacc=1 \
    bigbacc=0 cigbacc=0 nigbacc=1 aigbinv=0.35 \
    bigbinv=0.03 cigbinv=6E-3 eigbinv=1.1 nigbinv=3 \
    aigc=0.43 bigc=0.054 cigc=0.075 aigsd=0.43 \
    bigsd=0.054 cigsd=0.075 dlcig=0 nigc=1 \
    poxedge=1 pigcd=1 ntox=1 toxref=4.148E-9 \
    agidl=0 bgidl=2.3E9 cgidl=0.5 egidl=0.8 \
    noia=9E41 noib=1E27 noic=8E11 em=4.1E7 \
    af=1 ef=1.2 kf=0 lintnoi=-3E-7 \
    tnoia=2.5E7 tnoib=9.9E6 ntnoi=1 rnoia=0.912 \
    rnoib=0.26 xpart=0 cgso=2.392894381e-10 cgdo=2.392894381e-10 \
    cgbo=1e-14 ckappas=0.6 cf=1E-14 clc=1E-7 \
    cle=0.6 dlc=1.21071E-8 dwc=2.6E-8 vfbcv=-1 \
    noff=3.8661 voffcv=-0.16994 acde=0.38008 moin=23.81 \
    cgsl=2.310725e-11 cgdl=2.310725e-11 ijthsrev=0.1 ijthsfwd=0.1 \
    xjbvs=1 bvs=11.9 jss=2.75E-3 jsws=6E-10 \
    cjs=0.00121 mjs=0.42197 mjsws=1E-3 cjsws=3.230311424e-11 \
    cjswgs=1.795291232e-10 mjswgs=0.8 pbs=0.7477 pbsws=0.1 \
    pbswgs=0.79644 xrcrg1=12 xrcrg2=1 rbpb=50 \
    rbpd=50 rbps=50 rbdb=50 rbsb=50 \
    gbmin=1E-12 tnom=30 ute=-2.841387833333333 lute=1.462012276083332E-7 \
    kt1=-0.295119316666667 lkt1=-2.874265065833337E-9 kt1l=0 kt2=0.02122778 \
    lkt2=-5.743292291000001E-9 ua1=-2.42902207E-9 lua1=3.816539507165E-16 ub1=2.4443796E-18 \
    lub1=-4.0006627012E-25 uc1=5.2148775E-12 luc1=-5.195283211249999E-19 at=6.394335E4 \
    lat=2.4945216175E-3 prt=0 njs=1.2928 xtis=2 \
    tpb=1.2287E-3 tpbsw=0 tpbswg=0 tcj=7.92E-4 \
    tcjsw=1E-5 tcjswg=0 tvoff=0 tvfbsdoff=0 \
    saref=1.1E-6 sbref=1.1E-6 wlod=0 ku0=-2.7E-8 \
    kvsat=0.2 kvth0=7.9E-9 tku0=0 llodku0=0 \
    wlodku0=1 llodvth=0 wlodvth=1 lku0=0 \
    wku0=0 pku0=0 lkvth0=0 wkvth0=3E-7 \
    pkvth0=0 stk2=0 lodk2=1 steta0=0 \
    lodeta0=1 rsh=485.6850789096126

// l=0.15 w=69.7 nf=35 -> bin nlowvt_model.8  rsh=488.2418 delvto=0 (folded into vth0)
model nlowvt_model__w69p7nf35 bsim4 \
    type=n version=4.50 binunit=2 mobmod=0 \
    capmod=2 rdsmod=0 igcmod=0 igbmod=0 \
    rbodymod=1 trnqsmod=0 acnqsmod=0 fnoimod=1 \
    tnoimod=1 diomod=1 tempmod=0 permod=1 \
    geomod=0 rgatemod=0 epsrox=3.9 toxe=4.148E-9 \
    toxm=4.148E-9 dtox=0 xj=1.5E-7 ndep=1.7E17 \
    ngate=9.999999999999999E22 nsd=1E20 rshg=0.1 phin=0 \
    wint=2.6e-08 wl=0 wln=1 ww=0 \
    wwn=1 wwl=0 lint=1.2025e-08 ll=0 \
    lln=1 lw=0 lwn=1 lwl=0 \
    llc=0 lwc=0 lwlc=0 wlc=0 \
    wwc=0 wwlc=0 dwg=-1.33E-8 dwb=-1.08E-8 \
    xl=0 xw=0 dmcg=0 dmdg=0 \
    dmcgt=0 xgw=0 xgl=0 ngcon=1 \
    vth0=0.249959346666667 lvth0=-1.985141612666671E-9 vfb=0 k1=1.011211866666667 \
    lk1=-4.876429660666666E-8 k2=-0.21737859252 lk2=1.7355223637994E-8 k3=1.65 \
    k3b=1.6 w0=1E-7 lpe0=2.3802E-7 lpeb=-4.9152E-8 \
    vbm=-3 dvtp0=0 dvtp1=0 dvt0=0.07665 \
    dvt1=0.1252 dvt2=-0.05637 dvt0w=0 dvt1w=5.3E6 \
    dvt2w=-0.032 vfbsdoff=0 u0=0.01421071555 lu0=2.166698264775001E-10 \
    ua=-3.496851672833332E-9 lua=1.729222681883582E-16 ub=4.57941585E-18 lub=-2.719028563075E-25 \
    uc=1.863698448333334E-10 luc=-2.261771620175834E-17 ud=0 up=0 \
    lp=1 eu=1.67 vsat=1.819855189500001E5 lvsat=-1.786254255252507E-3 \
    a0=0 ags=1.005218833333333 lags=3.096873294166675E-8 b0=0 \
    b1=0 keta=0.1569286063 lketa=-4.276737497598501E-8 a1=0 \
    a2=0.38689047 rdsw=103.65 rdswmin=0 rdw=0 \
    rdwmin=0 rsw=0 rswmin=0 prwb=0 \
    prwg=0 wr=1 voff=-0.11934831869 lvoff=5.296050099455504E-9 \
    voffl=0 minv=0 nfactor=0.723459400166666 lnfactor=3.583940752490084E-7 \
    eta0=0.067637351756667 leta0=1.529144370447834E-9 etab=-0.077077273825 letab=9.70788263825875E-9 \
    dsub=0.58180516425 ldsub=-4.053136043728748E-8 cit=5E-6 cdsc=3.8556E-37 \
    cdscb=-1.1484E-4 cdscd=4.7984E-6 pclm=0.086824416666667 lpclm=9.59179572083335E-9 \
    pdiblc1=3.583688213883334 lpdiblc1=-4.029261769551058E-7 pdiblc2=0.064735802833333 lpdiblc2=-7.957785851858334E-9 \
    pdiblcb=0 drout=3.4946 pscbe1=4.5E8 pscbe2=1E-8 \
    pvag=0 delta=0.01 fprout=0 pdits=1.4427E-15 \
    pditsl=0 pditsd=0 lambda=0 vtl=0 \
    lc=0 xn=0 alpha0=1.687407635666667E-3 lalpha0=-1.627859334572167E-10 \
    alpha1=0 beta0=31.24083182666667 lbeta0=-3.496153888186668E-7 aigbacc=1 \
    bigbacc=0 cigbacc=0 nigbacc=1 aigbinv=0.35 \
    bigbinv=0.03 cigbinv=6E-3 eigbinv=1.1 nigbinv=3 \
    aigc=0.43 bigc=0.054 cigc=0.075 aigsd=0.43 \
    bigsd=0.054 cigsd=0.075 dlcig=0 nigc=1 \
    poxedge=1 pigcd=1 ntox=1 toxref=4.148E-9 \
    agidl=0 bgidl=2.3E9 cgidl=0.5 egidl=0.8 \
    noia=9E41 noib=1E27 noic=8E11 em=4.1E7 \
    af=1 ef=1.2 kf=0 lintnoi=-3E-7 \
    tnoia=2.5E7 tnoib=9.9E6 ntnoi=1 rnoia=0.912 \
    rnoib=0.26 xpart=0 cgso=2.392894381e-10 cgdo=2.392894381e-10 \
    cgbo=1e-14 ckappas=0.6 cf=1E-14 clc=1E-7 \
    cle=0.6 dlc=1.21071E-8 dwc=2.6E-8 vfbcv=-1 \
    noff=3.8661 voffcv=-0.16994 acde=0.38008 moin=23.81 \
    cgsl=2.310725e-11 cgdl=2.310725e-11 ijthsrev=0.1 ijthsfwd=0.1 \
    xjbvs=1 bvs=11.9 jss=2.75E-3 jsws=6E-10 \
    cjs=0.00121 mjs=0.42197 mjsws=1E-3 cjsws=3.230311424e-11 \
    cjswgs=1.795291232e-10 mjswgs=0.8 pbs=0.7477 pbsws=0.1 \
    pbswgs=0.79644 xrcrg1=12 xrcrg2=1 rbpb=50 \
    rbpd=50 rbps=50 rbdb=50 rbsb=50 \
    gbmin=1E-12 tnom=30 ute=-2.841387833333333 lute=1.462012276083332E-7 \
    kt1=-0.295119316666667 lkt1=-2.874265065833337E-9 kt1l=0 kt2=0.02122778 \
    lkt2=-5.743292291000001E-9 ua1=-2.42902207E-9 lua1=3.816539507165E-16 ub1=2.4443796E-18 \
    lub1=-4.0006627012E-25 uc1=5.2148775E-12 luc1=-5.195283211249999E-19 at=6.394335E4 \
    lat=2.4945216175E-3 prt=0 njs=1.2928 xtis=2 \
    tpb=1.2287E-3 tpbsw=0 tpbswg=0 tcj=7.92E-4 \
    tcjsw=1E-5 tcjswg=0 tvoff=0 tvfbsdoff=0 \
    saref=1.1E-6 sbref=1.1E-6 wlod=0 ku0=-2.7E-8 \
    kvsat=0.2 kvth0=7.9E-9 tku0=0 llodku0=0 \
    wlodku0=1 llodvth=0 wlodvth=1 lku0=0 \
    wku0=0 pku0=0 lkvth0=0 wkvth0=3E-7 \
    pkvth0=0 stk2=0 lodk2=1 steta0=0 \
    lodeta0=1 rsh=488.24175035868006
